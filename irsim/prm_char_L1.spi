* prm_char_L1.spi -- auto-generated by script/gen_prm_characterize.py
* DO NOT hand-edit -- regenerate instead.
*
* IRSIM's official resistance-table characterization circuit
* (lib/calibrate_spice3/ckt.spi in the irsim source tree,
* https://github.com/RTimothyEdwards/irsim), adapted for ngspice and this
* project's real TR-1um PMOS/NMOS models. See gen_prm_characterize.py's
* module docstring for the full methodology.
*
* W=10.2u(P)/3.4u(N)  L=1u  Cap=1000fF  Vdd=5.0V

.include '~/Dropbox/91_OpenPDK/TR-1um/libs.tech/spice/models/ip62_models'

* NOTE: the local ground rail is named VSS, not GND -- ngspice (like this
* project's own testbenches, e.g. simulations/IO_DC.spice) treats "gnd"
* as a reserved alias for node 0, so a node literally named GND tied to 0
* via a source is a short-circuit ("shorted VSRC") in ngspice.

* out1 -- self-driven inverter (fast input edge)
XP1 out1 in1 VDD VDD PMOS w=10.2u l=1u nrd=0 nrs=0
XN1 out1 in1 VSS VSS NMOS w=3.4u l=1u nrd=0 nrs=0

* out2 -- second inverter, driven BY out1 (realistic/slow input edge)
XP2 out2 out1 VDD VDD PMOS w=10.2u l=1u nrd=0 nrs=0
XN2 out2 out1 VSS VSS NMOS w=3.4u l=1u nrd=0 nrs=0

* out3 -- lone NFET pulling UP (source=VDD, drain=out3): n-channel
* dynamic-high (NMOS's weak direction)
XN3 out3 in2 VDD VSS NMOS w=3.4u l=1u nrd=0 nrs=0

* out4 -- lone PFET pulling DOWN (source=VSS, drain=out4): p-channel
* dynamic-low (PMOS's weak direction)
XP4 out4 in3 VSS VDD PMOS w=10.2u l=1u nrd=0 nrs=0

Cout1 out1 0 1000f
Cout2 out2 0 1000f
Cout3 out3 0 1000f
Cout4 out4 0 1000f

VVDD VDD 0 DC 5.0
VVSS VSS 0 DC 0

* fast (<=0.1ns) edges, matching IRSIM's own calibration procedure exactly
Vin1 in1 0 PWL(0n 0 0.1n 5.0 40n 5.0 40.1n 0)
Vin2 in2 0 PWL(0n 0 0.1n 5.0)
Vin3 in3 0 PWL(0n 5.0 0.1n 0)

.ic V(out4)=5.0

.control
  tran 0.01n 80n
  set filetype=ascii
  write prm_char_L1.raw
.endc

.end
