* dffrb_reset_tb.spi -- auto-generated by script/gen_dffrb_reset_tb.py
* DO NOT hand-edit -- regenerate instead.
*
* Real transistor-level check of DFFRB's slave-latch node QS after
* RSTB releases, with CK held fixed (never toggled) -- see
* gen_dffrb_reset_tb.py's module docstring and design_notes.md 76.30/
* 76.31 for the full motivation. Vdd=5.0V, matching this project's own
* other testbenches (simulations/*_AC.spice, simulations/IO_DC.spice).
*
* NOTE: local ground rail is VSS, not GND -- see the DFFRB_BODY's own
* GND formal pin name is fine (it's a subcircuit-local formal name, not
* a top-level node), but the top-level instantiation below binds it to
* VSS (this testbench's actual ground net), avoiding ngspice's reserved
* "gnd" alias for node 0 (design_notes.md 76.29's ngspice error).

.include '~/Dropbox/91_OpenPDK/TR-1um/libs.tech/spice/models/ip62_models'

.subckt DFFRB VDD QB D Q RSTB GND CK
XM2 net1 D VDD VDD PMOS w=5.2u l=1u
XM1 net2 CKP net1 VDD PMOS w=5.2u l=1u
XM7 net2 CKB net3 GND NMOS w=3.4u l=1u
XM8 net3 D GND GND NMOS w=3.4u l=1u
XM10 QM net2 VDD VDD PMOS w=5.2u l=1u
XM11 QM net2 GND GND NMOS w=3.4u l=1u
XM13 net4 QM GND GND NMOS w=3.4u l=1u
XM15 net4 CKP net2 GND NMOS w=3.4u l=1u
XM22 QB QS VDD VDD PMOS w=10.4u l=1u
XM3 net4 QM VDD VDD PMOS w=5.2u l=1u
XM4 net2 CKB net4 VDD PMOS w=5.2u l=1u
XM5 QS CKP QM GND NMOS w=3.4u l=1u
XM6 QM CKB QS VDD PMOS w=5.2u l=1u
XM9 net5 QB GND GND NMOS w=3.4u l=1u
XM12 net5 QB VDD VDD PMOS w=5.2u l=1u
XM14 net5 CKB QS GND NMOS w=3.4u l=1u
XM16 QS CKP net5 VDD PMOS w=5.2u l=1u
XM17 QB RSTB net6 GND NMOS w=3.4u l=1u
XM18 Q QB VDD VDD PMOS w=10.4u l=1u
XM19 Q QB GND GND NMOS w=3.4u l=1u
XM20 CKB CK VDD VDD PMOS w=10.4u l=1u
XM21 CKB CK GND GND NMOS w=3.4u l=1u
XM23 CKP CKB VDD VDD PMOS w=10.4u l=1u
XM24 CKP CKB GND GND NMOS w=3.4u l=1u
XM25 net6 QS GND GND NMOS w=3.4u l=1u
XM26 QB RSTB VDD VDD PMOS w=10.4u l=1u
.ends DFFRB

* Instantiate DFFRB, binding its formal GND pin to our real VSS node.
X1 VDD QB D Q RSTB VSS CK DFFRB

VVDD VDD 0 DC 5.0
VVSS VSS 0 DC 0

* D and CK held fixed -- this test is about QS's own retention, not
* data capture. CK held HIGH, matching this project's SCL-idle-high
* convention (preamble()/gen_reset_check() hold SCL high at rest).
VD D 0 DC 0
VCK CK 0 DC 5.0

* RSTB: pulsed low (asserted, active-low) for 100ns, then released and
* left high for the rest of a long transient.
VRSTB RSTB 0 PWL(0n 0 1n 0 2n 5.0 100n 5.0 101n 5.0)

* Give QS the same "force QS=0" initial condition the .cmd scripts use,
* right before RSTB releases -- then nothing touches it again. Does it
* actually hold near 0V, or drift?
.ic V(x1.qs)=0

* Print interval 10ns, out to 40us -- comfortably covers this session's
* longest real IRSIM test (irsim_test_main.cmd, ends ~t=39260ns), i.e.
* if QS still hasn't drifted through a threshold by 40us, the "force
* once at cold start and let it hold" approach is realistic for every
* test actually run this session. 4000 output points -- small/fast.
.control
  tran 10n 40u uic
  set filetype=ascii
  write dffrb_reset_tb.raw
  print v(rstb) v(x1.qs) v(x1.qb) v(x1.q) > dffrb_reset_tb_print.txt
.endc

.end
