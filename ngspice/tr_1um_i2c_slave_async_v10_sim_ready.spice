* tr_1um_i2c_slave_async_v10_sim_ready.spice -- auto-generated by
* script/gen_chip_sim_ready_v10.py, from:
*   /sessions/dreamy-ecstatic-heisenberg/mnt/TR-1um_Async_I2C/schematic/tr_1um_i2c_slave_async_v10_lvs.spice
* (the LVS-confirmed-clean V10 chip netlist, RING_OSC excluded -- see
* this script's own module docstring for why the source file already
* excludes RING_OSC with no manual stripping needed). Mechanical
* fixes applied on top of the verbatim source, all required for a
* real ngspice run (none change electrical intent) -- same fix classes
* as V9's gen_chip_sim_ready_v9.py, whose docstring has the full
* diagnosis/rationale for each:
*   1) all 378 bare M-line transistor instances -> X-line
*      (subckt-call) form, so ip62_models' PMOS/NMOS .subckt wrappers
*      resolve them (KLayout's own bare-M LVS convention doesn't).
*   2) 37 bracket-vector net names (145
*      occurrences, e.g. tx_data[0] -> tx_data_0), everywhere they
*      appear.
*   3) 2 malformed comment-continuation line(s) in the
*      i2c_slave_async_nrow_fm PININFO block (bare "+" -> "*+") --
*      the real root cause of V9's own "too few nodes" ngspice error
*      on the x2 instantiation; see gen_chip_sim_ready_v9.py's
*      docstring fix #3 for the full diagnosis.
*   4) 4 diode instance parameter(s) renamed A=/P= ->
*      AREA=/PJ= (DD1/DD2 inside OSS_ESD_5V_DIO) -- ngspice's native
*      diode instance parser doesn't accept the short forms KLayout's
*      LVS writer emits; values unchanged, purely a keyword-spelling
*      fix.
*   5) 4 bare-M devices (originally model=NMOSE, all inside
*      the OSS_ESD_5V_* pad-ESD cells) renamed to model=MNE -- NMOSE is
*      a KLayout DRC/LVS device-recognition label with no SPICE-library
*      counterpart; MNE is ip62_models' extended-drain NMOS and what
*      these cells' own source xschem schematic actually specifies
*      (property model=MNE) -- see gen_chip_sim_ready_v9.py's docstring
*      for the full cross-check (same ESD cells, unchanged from v9).
*      This is the best-supported mapping found but IS an inference;
*      sanity-check ESD-cell nodes on first real run.
* DO NOT hand-edit -- regenerate instead.

** tr_1um_i2c_slave_async_v10_lvs.spice -- chip-level LVS reference netlist (V10,
** core+GIO only -- RING_OSC not yet integrated, see
** gen_lvs_spice_ringosc_v10.py for that).
** Generated by script/gen_lvs_spice_top_v10.py from:
**   1) schematic/i2c_slave_async_nrow_fm_v10.spice (core, LVS-clean per
**      design_notes.md 108.51 -- "V10コアセル単体LVSクリーン達成")
**   2) simulations/OSS_FRAME_GIO.spice (GIO pad-ring frame, transistor
**      level, unchanged from V9 -- same physical frame)
**   3) schematic/gio_connections.json (base GIO<->core connection map,
**      derived + cross-verified design_notes.md 78.1/78.4 for V9) with
**      the 20 signal-net terminals OVERRIDDEN from
**      schematic/v10_signal_routing_plan.json's own per-net "terminal"
**      field (V10's pad-pairing-aware reassignment, design_notes.md
**      108.57) -- see this script's own module docstring for exactly
**      which terminals differ from V9's assignment and why the rest of
**      the 43-terminal map is safely reused verbatim.
** x1 = OSS_FRAME_GIO, x2 = i2c_slave_async_nrow_fm. Nets prefixed NC_
** are genuinely unconnected on both sides -- each gets its own unique
** floating net name so LVS sees them as independently floating,
** matching the real chip.
** Top subckt declares its 16 real bond-pad ports explicitly (P1-P7,
** VSS, P9-P15, VDD -- P8 does not exist in this frame), matching v9's
** own top-level-pin fix (design_notes.md 79.13).

** sch_path: /Users/okamura/Dropbox/91_OpenPDK/TR-1um/libs.tech/xschem/TR-1um_frame/OSS_FRAME_GIO.sch
.subckt OSS_FRAME_GIO P1 VDD P2 P15 P14 P3 P4 P13 P5 P12 P6 P11 P10 P7 P9 VSS HIZ1 HIZ2 HIZ9 HIZ10 HIZ3 HIZ4 HIZ11 HIZ5 HIZ12 HIZ6
+ HIZ13 HIZ14 HIZ7 HIZ15 OUT1 OUT2 OUT9 OUT10 OUT3 OUT4 OUT11 OUT5 OUT12 OUT6 OUT13 OUT14 OUT7 OUT15
*.PININFO P1:B P2:B P3:B P4:B P5:B P6:B P7:B VSS:B VDD:B P15:B P14:B P13:B P12:B P11:B P10:B P9:B HIZ1:I OUT1:I HIZ2:I OUT2:I
*+ HIZ3:I OUT3:I HIZ4:I OUT4:I HIZ5:I OUT5:I HIZ6:I OUT6:I HIZ7:I OUT7:I HIZ15:I OUT15:I HIZ14:I OUT14:I HIZ13:I OUT13:I HIZ12:I OUT12:I
*+ HIZ11:I OUT11:I HIZ10:I OUT10:I HIZ9:I OUT9:I
x1 VDD P1 VSS HIZ1 OUT1 OSS_ESD_5V_DIO
x2 VDD VSS OSS_ESD_5V_VDD
x3 VDD VSS OSS_ESD_5V_VSS
x4 VDD P2 VSS HIZ2 OUT2 OSS_ESD_5V_DIO
x5 VDD P3 VSS HIZ3 OUT3 OSS_ESD_5V_DIO
x6 VDD P4 VSS HIZ4 OUT4 OSS_ESD_5V_DIO
x7 VDD P5 VSS HIZ5 OUT5 OSS_ESD_5V_DIO
x8 VDD P6 VSS HIZ6 OUT6 OSS_ESD_5V_DIO
x9 VDD P7 VSS HIZ7 OUT7 OSS_ESD_5V_DIO
x10 VDD P15 VSS HIZ15 OUT15 OSS_ESD_5V_DIO
x11 VDD P14 VSS HIZ14 OUT14 OSS_ESD_5V_DIO
x12 VDD P13 VSS HIZ13 OUT13 OSS_ESD_5V_DIO
x13 VDD P12 VSS HIZ12 OUT12 OSS_ESD_5V_DIO
x14 VDD P11 VSS HIZ11 OUT11 OSS_ESD_5V_DIO
x15 VDD P10 VSS HIZ10 OUT10 OSS_ESD_5V_DIO
x16 VDD P9 VSS HIZ9 OUT9 OSS_ESD_5V_DIO
.ends

* expanding   symbol:  OSS_ESD_5V_DIO.sym # of pins=6
** sym_path: /Users/okamura/Dropbox/91_OpenPDK/TR-1um/libs.tech/xschem/TR-1um_frame/OSS_ESD_5V_DIO.sym
** sch_path: /Users/okamura/Dropbox/91_OpenPDK/TR-1um/libs.tech/xschem/TR-1um_frame/OSS_ESD_5V_DIO.sch
.subckt OSS_ESD_5V_DIO VDD PAD VSS HIZ OUT
*.PININFO PAD:B VDD:B VSS:B HIZ:I OUT:I
XXM1 PAD PG VDD VDD PMOS w=300u l=2u
XXM2 PAD NG VSS VSS MNE w=150u l=2u
XXM3 PG PGG VDD VDD PMOS w=20.8u l=1u
XXM4 PG PGG VSS VSS NMOS w=6.8u l=1u
XXM5 PAD VDD VDD VDD PMOS w=200u l=2u
XXM6 PAD VSS VSS VSS MNE w=350u l=2u
XXM7 NG NGG VDD VDD PMOS w=20.8u l=1u
XXM8 NG NGG VSS VSS NMOS w=6.8u l=1u
XXM9 PGG HIZ net2 VDD PMOS w=10.4u l=1u
XXM10 net2 net1 VDD VDD PMOS w=10.4u l=1u
XXM11 PGG net1 VSS VSS NMOS w=3.4u l=1u
XXM12 PGG HIZ VSS VSS NMOS w=3.4u l=1u
XXM13 NGG net1 VDD VDD PMOS w=5.2u l=1u
XXM14 NGG ENB VDD VDD PMOS w=5.2u l=1u
XXM15 NGG ENB net3 VSS NMOS w=3.4u l=1u
XXM16 net3 net1 VSS VSS NMOS w=3.4u l=1u
XXM17 ENB HIZ VDD VDD PMOS w=5.2u l=1u
XXM18 ENB HIZ VSS VSS NMOS w=3.4u l=1u
DD1 VSS HIZ DN AREA=12.96p PJ=14.4u
XXM19 net1 OUT VDD VDD PMOS w=5.2u l=1u
XXM20 net1 OUT VSS VSS NMOS w=3.4u l=1u
DD2 VSS OUT DN AREA=12.96p PJ=14.4u
.ends

* expanding   symbol:  OSS_ESD_5V_VDD.sym # of pins=3
** sym_path: /Users/okamura/Dropbox/91_OpenPDK/TR-1um/libs.tech/xschem/TR-1um_frame/OSS_ESD_5V_VDD.sym
** sch_path: /Users/okamura/Dropbox/91_OpenPDK/TR-1um/libs.tech/xschem/TR-1um_frame/OSS_ESD_5V_VDD.sch
.subckt OSS_ESD_5V_VDD VDD VSS
*.PININFO VSS:B VDD:B VDD:B
XXM5 VSS VDD VDD VDD PMOS w=500u l=2u
XXM6 VDD VSS VSS VSS MNE w=500u l=2u
.ends

* expanding   symbol:  OSS_ESD_5V_VSS.sym # of pins=3
** sym_path: /Users/okamura/Dropbox/91_OpenPDK/TR-1um/libs.tech/xschem/TR-1um_frame/OSS_ESD_5V_VSS.sym
** sch_path: /Users/okamura/Dropbox/91_OpenPDK/TR-1um/libs.tech/xschem/TR-1um_frame/OSS_ESD_5V_VSS.sch
.subckt OSS_ESD_5V_VSS VDD VSS
*.PININFO VSS:B VDD:B VSS:B
XXM3 VSS VDD VDD VDD PMOS w=500u l=2u
XXM4 VDD VSS VSS VSS MNE w=500u l=2u
.ends

** Generated by script/gen_lvs_spice_v10.py from i2c_slave_async_net_v10_final.v
** (MUXDFFRB/RSLATCH bodies sourced from simulations/MUXDFFRB.spice and
** simulations/RSLATCH.spice per user instruction -- see module docstring)
.subckt i2c_slave_async_nrow_fm rst_n scl sda_in tx_data_0 tx_data_1 tx_data_2 tx_data_3 tx_data_4
+ tx_data_5 tx_data_6 tx_data_7 sda_oe rx_data_0 rx_data_1 rx_data_2 rx_data_3 rx_data_4 rx_data_5
+ rx_data_6 rx_data_7 rx_valid addr_match rw busy VDD GND
*.PININFO rst_n:I scl:I sda_in:I tx_data_0:I tx_data_1:I tx_data_2:I tx_data_3:I tx_data_4:I tx_data_5:I
*+ tx_data_6:I tx_data_7:I sda_oe:O rx_data_0:O rx_data_1:O rx_data_2:O rx_data_3:O rx_data_4:O
*+ rx_data_5:O rx_data_6:O rx_data_7:O rx_valid:O addr_match:O rw:O busy:O VDD:B GND:B
x_380_ VDD bit_cnt_0 _079_ GND INV_X1
x_381_ VDD addr_match _080_ GND INV_X1
x_382_ VDD rst_n _081_ GND INV_X1
x_383_ VDD sda_d _082_ GND INV_X1
x_384_ VDD _083_ scl_row1 sda_d GND NAND2
x_385_ VDD _167_ sda_in_row1 _083_ GND NOR2
x_386_ VDD _143_ _081_ _167_ GND OR2
x_387_ VDD _016_ rst_scl_domain_held _143_ GND NOR2
x_388_ VDD _017_ busy rst_n GND AND2_X1
x_389_ VDD _084_ phase_2 _209_ GND OR2
x_390_ VDD _085_ _210_ _084_ GND OR2
x_391_ VDD _085_ rx_valid GND INV_X1
x_392_ phase_0 _209_ VDD _086_ phase_2 GND NOR3
x_393_ VDD _087_ last_bit_pending _086_ GND NAND2
xu_muxdffrb_1 VDD shreg_5 rx_data_6 rx_data_6 _156_ _087_ _195_ GND _016_ MUXDFFRB
xu_muxdffrb_2 VDD shreg_4 rx_data_5 rx_data_5 _156_ _087_ _196_ GND _016_ MUXDFFRB
xu_muxdffrb_3 VDD shreg_3 rx_data_4 rx_data_4 _156_ _087_ _197_ GND _016_ MUXDFFRB
xu_muxdffrb_4 VDD shreg_2 rx_data_3 rx_data_3 _156_ _087_ _198_ GND _016_ MUXDFFRB
xu_muxdffrb_5 VDD shreg_1 rx_data_2 rx_data_2 _156_ _087_ _199_ GND _016_ MUXDFFRB
xu_muxdffrb_6 VDD shreg_0 rx_data_1 rx_data_1 _156_ _087_ _200_ GND _016_ MUXDFFRB
xu_muxdffrb_7 VDD sda_in_row2 rx_data_0 rx_data_0 _156_ _087_ _201_ GND _016_ MUXDFFRB
x_401_ VDD _088_ bit_cnt_1 bit_cnt_0 GND NOR2
x_402_ phase_0 phase_1 VDD _089_ _216_ GND NOR3
x_403_ phase_1 VDD _090_ _216_ phase_0 GND OR3
x_404_ VDD _091_ bit_cnt_2 _090_ GND NOR2
x_405_ VDD _092_ _088_ _091_ GND NAND2
xu_muxdffrb_8 VDD tx_data_6 txreg_6 txreg_6 scl_n_row1 _092_ _202_ GND _017_ MUXDFFRB
xu_muxdffrb_9 VDD tx_data_5 txreg_5 txreg_5 scl_n_row3 _092_ _203_ GND _017_ MUXDFFRB
xu_muxdffrb_10 VDD tx_data_4 txreg_4 txreg_4 scl_n_row3 _092_ _204_ GND _017_ MUXDFFRB
xu_muxdffrb_11 VDD tx_data_3 txreg_3 txreg_3 scl_n_row3 _092_ _205_ GND _017_ MUXDFFRB
xu_muxdffrb_12 VDD tx_data_2 txreg_2 txreg_2 scl_n_row3 _092_ _206_ GND _017_ MUXDFFRB
xu_muxdffrb_13 VDD tx_data_1 txreg_1 txreg_1 scl_n_row3 _092_ _207_ GND _017_ MUXDFFRB
xu_muxdffrb_14 VDD tx_data_0 txreg_0 txreg_0 scl_n_row3 _092_ _208_ GND _017_ MUXDFFRB
x_413_ phase_0 phase_1 VDD _093_ phase_2 GND NOR3
x_414_ _089_ _093_ VDD _094_ _086_ GND NOR3
x_415_ VDD _095_ last_bit_pending _094_ GND NOR2
x_416_ VDD _096_ _210_ phase_1 GND OR2
x_417_ _210_ phase_1 VDD _097_ _216_ GND NOR3
x_418_ VDD _098_ _216_ _096_ GND OR2
x_419_ VDD _099_ phase_2 _096_ GND OR2
x_420_ _099_ _098_ VDD _100_ _085_ _094_ GND AND4_X1
x_421_ VDD _101_ sda_in_row0 _097_ GND NAND2
x_422_ VDD _102_ _080_ _215_ GND NOR2
x_423_ VDD _103_ _099_ _102_ GND NOR2
x_424_ VDD _104_ _087_ _101_ GND NAND2
x_425_ rx_valid _100_ _103_ _104_ VDD _105_ GND OR4
xu_muxdffrb_15 VDD _105_ phase_1 phase_1 _156_ _095_ _209_ GND _016_ MUXDFFRB
x_427_ VDD _106_ last_bit_pending _093_ GND NAND2
x_428_ VDD _107_ last_bit_pending _089_ GND NAND2
x_429_ _107_ VDD _064_ _087_ _106_ GND NAND3
x_430_ VDD _108_ bit_cnt_1 _100_ GND NAND2
x_431_ last_bit_pending _094_ VDD _109_ phase_2 GND NOR3
x_432_ VDD _110_ last_bit_pending _090_ GND AND2_X1
x_433_ VDD _111_ _094_ _110_ GND NOR2
x_434_ VDD _112_ bit_cnt_1 bit_cnt_0 GND NAND2
x_435_ VDD _113_ bit_cnt_1 bit_cnt_0 GND XOR2
x_436_ VDD _114_ _111_ _113_ GND NAND2
x_437_ VDD _065_ _108_ _114_ GND NAND2
x_438_ VDD _115_ bit_cnt_0 _100_ GND NAND2
x_439_ VDD _116_ _212_ _111_ GND NAND2
x_440_ VDD _066_ _115_ _116_ GND NAND2
x_441_ _194_ _191_ shreg_5 shreg_2 VDD _117_ GND OR4
x_442_ shreg_3 shreg_0 shreg_1 _117_ VDD _118_ GND NOR4
xu_muxdffrb_16 VDD _118_ addr_match addr_match _156_ _106_ _213_ GND _016_ MUXDFFRB
x_444_ VDD _119_ bit_cnt_2 _100_ GND NAND2
x_445_ VDD _120_ bit_cnt_2 _112_ GND XNOR2
x_446_ VDD _121_ _111_ _120_ GND NAND2
x_447_ VDD _068_ _119_ _121_ GND NAND2
xu_muxdffrb_17 VDD sda_in_row1 rw rw _156_ _106_ _215_ GND _016_ MUXDFFRB
x_449_ VDD _122_ _080_ rw GND NOR2
x_450_ VDD _123_ _099_ _122_ GND NOR2
x_451_ _097_ _100_ _111_ _123_ VDD _124_ GND NOR4
x_452_ VDD _070_ _109_ _124_ GND NOR2
xu_muxdffrb_18 VDD tx_data_7 txreg_7 txreg_7 scl_n_row1 _092_ _217_ GND _017_ MUXDFFRB
xu_muxdffrb_19 VDD shreg_6 rx_data_7 rx_data_7 _156_ _087_ _188_ GND _016_ MUXDFFRB
x_455_ tx_data_7 txreg_5 bit_cnt_1 VDD _125_ GND MUX2
x_456_ VDD _126_ _079_ _125_ GND NAND2
x_457_ txreg_6 txreg_4 bit_cnt_1 VDD _127_ GND MUX2
x_458_ VDD _128_ bit_cnt_0 _127_ GND NAND2
x_459_ _128_ VDD _129_ _091_ _126_ GND NAND3
x_460_ VDD _130_ bit_cnt_2 _089_ GND NAND2
x_461_ txreg_2 txreg_0 bit_cnt_1 VDD _131_ GND MUX2
x_462_ txreg_3 txreg_1 bit_cnt_1 VDD _132_ GND MUX2
x_463_ _131_ _132_ _079_ VDD _133_ GND MUX2
x_464_ VDD _134_ _130_ _133_ GND NOR2
x_465_ VDD _135_ _080_ _099_ GND NOR2
x_466_ _134_ _135_ VDD _136_ rx_valid GND NOR3
x_467_ VDD _005_ _129_ _136_ GND NAND2
x_468_ _211_ _214_ VDD _004_ bit_cnt_0 GND NOR3
x_469_ VDD _156_ scl_row1 _016_ GND AND2_X1
x_470_ VDD _144_ _081_ scl_row1 GND NOR2
x_471_ _082_ VDD _137_ sda_in_row1 scl_row1 GND NAND3
x_472_ VDD _077_ rst_n _137_ GND NAND2
x_505_ VDD _212_ _066_ bit_cnt_0 _016_ GND _156_ DFFRB
x_506_ VDD _211_ _065_ bit_cnt_1 _016_ GND _156_ DFFRB
x_507_ VDD _214_ _068_ bit_cnt_2 _016_ GND _156_ DFFRB
x_509_ VDD _210_ _064_ phase_0 _016_ GND _156_ DFFRB
x_511_ VDD _216_ _070_ phase_2 _016_ GND _156_ DFFRB
x_528_ VDD sda_oe _005_ sda_oe_r _017_ GND scl_n_row2 DFFRB
x_529_ VDD _186_ _004_ last_bit_pending _016_ GND _156_ DFFRB
x_530_ VDD _192_ sda_in_row3 shreg_0 _016_ GND _156_ DFFRB
x_531_ VDD _189_ shreg_0 shreg_1 _016_ GND _156_ DFFRB
x_532_ VDD _190_ shreg_1 shreg_2 _016_ GND _156_ DFFRB
x_533_ VDD _193_ shreg_2 shreg_3 _016_ GND _156_ DFFRB
x_534_ VDD _191_ shreg_3 shreg_4 _016_ GND _156_ DFFRB
x_535_ VDD _218_ shreg_4 shreg_5 _016_ GND _156_ DFFRB
x_536_ VDD _194_ shreg_5 shreg_6 _016_ GND _156_ DFFRB
xu_inv_scl VDD scl_row1 scl_n GND INV_X1
xu_rslatch_1 VDD _167_ busy _077_ qn GND RSLATCH
xu_rslatch_2 VDD _143_ rst_scl_domain_held _144_ rst_stretch_qn GND RSLATCH
xu_sda_lat_en VDD sda_lat_en busy scl_row1 GND NAND2
xu_rslatch_3 VDD s_in sda_d r_in qn_sda GND RSLATCH
xu_sda_r VDD r_in sda_target_n sda_lat_en GND AND2_X1
xu_sda_s VDD s_in sda_target sda_lat_en GND AND2_X1
xu_sda_target VDD sda_in_row1 busy VDD sda_target GND MUX2
xu_sda_target_n VDD sda_target sda_target_n GND INV_X1
xu_buf_scl_row1 VDD scl_buf scl_row1 GND BUF_X1
xu_buf_scl_n_row1 VDD scl_n scl_n_row1 GND BUF_X1
xu_buf_scl_n_row2 VDD scl_n scl_n_row2 GND BUF_X1
xu_buf_scl_n_row3 VDD scl_n scl_n_row3 GND BUF_X1
xu_bufth_scl VDD scl scl_buf GND BUFTH
xu_bufth_sda_in VDD sda_in sda_in_buf GND BUFTH
xu_buf_sda_in_row0 VDD sda_in_buf sda_in_row0 GND BUF_X1
xu_buf_sda_in_row1 VDD sda_in_buf sda_in_row1 GND BUF_X1
xu_buf_sda_in_row2 VDD sda_in_buf sda_in_row2 GND BUF_X1
xu_buf_sda_in_row3 VDD sda_in_buf sda_in_row3 GND BUF_X1
** FILL3 decoupling-cap devices (design_notes.md 77.47) --
** one PMOS+NMOS pair per real placed instance, L/W from real
** device extraction against LEF/TR-1um_STDCELL.gds.
** FILL2 is instantiated as a subcircuit instead, below
** (design_notes.md round-4 fix, 2026-08-31 -- see
** FILL2_SUBCKT_BODY's comment for why).
xFILL2_1 VDD GND FILL2
xFILL2_2 VDD GND FILL2
xFILL2_3 VDD GND FILL2
xFILL2_4 VDD GND FILL2
xFILL2_5 VDD GND FILL2
xFILL2_6 VDD GND FILL2
xFILL2_7 VDD GND FILL2
xFILL2_8 VDD GND FILL2
xFILL2_9 VDD GND FILL2
xFILL2_10 VDD GND FILL2
xFILL2_11 VDD GND FILL2
xFILL2_12 VDD GND FILL2
xFILL2_13 VDD GND FILL2
xFILL2_14 VDD GND FILL2
xFILL2_15 VDD GND FILL2
xFILL2_16 VDD GND FILL2
xFILL2_17 VDD GND FILL2
xFILL2_18 VDD GND FILL2
xFILL2_19 VDD GND FILL2
xFILL2_20 VDD GND FILL2
xFILL2_21 VDD GND FILL2
xFILL2_22 VDD GND FILL2
xFILL2_23 VDD GND FILL2
xFILL2_24 VDD GND FILL2
xFILL2_25 VDD GND FILL2
xFILL2_26 VDD GND FILL2
xFILL2_27 VDD GND FILL2
xFILL2_28 VDD GND FILL2
xFILL2_29 VDD GND FILL2
xFILL2_30 VDD GND FILL2
xFILL2_31 VDD GND FILL2
xFILL2_32 VDD GND FILL2
xFILL2_33 VDD GND FILL2
X_FILL3_1_p VDD GND VDD VDD PMOS w=21.2u l=8.6u
X_FILL3_1_n GND VDD GND GND NMOS w=13.1u l=8.6u
X_FILL3_2_p VDD GND VDD VDD PMOS w=21.2u l=8.6u
X_FILL3_2_n GND VDD GND GND NMOS w=13.1u l=8.6u
X_FILL3_3_p VDD GND VDD VDD PMOS w=21.2u l=8.6u
X_FILL3_3_n GND VDD GND GND NMOS w=13.1u l=8.6u
X_FILL3_4_p VDD GND VDD VDD PMOS w=21.2u l=8.6u
X_FILL3_4_n GND VDD GND GND NMOS w=13.1u l=8.6u
X_FILL3_5_p VDD GND VDD VDD PMOS w=21.2u l=8.6u
X_FILL3_5_n GND VDD GND GND NMOS w=13.1u l=8.6u
X_FILL3_6_p VDD GND VDD VDD PMOS w=21.2u l=8.6u
X_FILL3_6_n GND VDD GND GND NMOS w=13.1u l=8.6u
X_FILL3_7_p VDD GND VDD VDD PMOS w=21.2u l=8.6u
X_FILL3_7_n GND VDD GND GND NMOS w=13.1u l=8.6u
X_FILL3_8_p VDD GND VDD VDD PMOS w=21.2u l=8.6u
X_FILL3_8_n GND VDD GND GND NMOS w=13.1u l=8.6u
X_FILL3_9_p VDD GND VDD VDD PMOS w=21.2u l=8.6u
X_FILL3_9_n GND VDD GND GND NMOS w=13.1u l=8.6u
X_FILL3_10_p VDD GND VDD VDD PMOS w=21.2u l=8.6u
X_FILL3_10_n GND VDD GND GND NMOS w=13.1u l=8.6u
X_FILL3_11_p VDD GND VDD VDD PMOS w=21.2u l=8.6u
X_FILL3_11_n GND VDD GND GND NMOS w=13.1u l=8.6u
X_FILL3_12_p VDD GND VDD VDD PMOS w=21.2u l=8.6u
X_FILL3_12_n GND VDD GND GND NMOS w=13.1u l=8.6u
X_FILL3_13_p VDD GND VDD VDD PMOS w=21.2u l=8.6u
X_FILL3_13_n GND VDD GND GND NMOS w=13.1u l=8.6u
X_FILL3_14_p VDD GND VDD VDD PMOS w=21.2u l=8.6u
X_FILL3_14_n GND VDD GND GND NMOS w=13.1u l=8.6u
X_FILL3_15_p VDD GND VDD VDD PMOS w=21.2u l=8.6u
X_FILL3_15_n GND VDD GND GND NMOS w=13.1u l=8.6u
X_FILL3_16_p VDD GND VDD VDD PMOS w=21.2u l=8.6u
X_FILL3_16_n GND VDD GND GND NMOS w=13.1u l=8.6u
X_FILL3_17_p VDD GND VDD VDD PMOS w=21.2u l=8.6u
X_FILL3_17_n GND VDD GND GND NMOS w=13.1u l=8.6u
X_FILL3_18_p VDD GND VDD VDD PMOS w=21.2u l=8.6u
X_FILL3_18_n GND VDD GND GND NMOS w=13.1u l=8.6u
X_FILL3_19_p VDD GND VDD VDD PMOS w=21.2u l=8.6u
X_FILL3_19_n GND VDD GND GND NMOS w=13.1u l=8.6u
X_FILL3_20_p VDD GND VDD VDD PMOS w=21.2u l=8.6u
X_FILL3_20_n GND VDD GND GND NMOS w=13.1u l=8.6u
X_FILL3_21_p VDD GND VDD VDD PMOS w=21.2u l=8.6u
X_FILL3_21_n GND VDD GND GND NMOS w=13.1u l=8.6u
X_FILL3_22_p VDD GND VDD VDD PMOS w=21.2u l=8.6u
X_FILL3_22_n GND VDD GND GND NMOS w=13.1u l=8.6u
X_FILL3_23_p VDD GND VDD VDD PMOS w=21.2u l=8.6u
X_FILL3_23_n GND VDD GND GND NMOS w=13.1u l=8.6u
X_FILL3_24_p VDD GND VDD VDD PMOS w=21.2u l=8.6u
X_FILL3_24_n GND VDD GND GND NMOS w=13.1u l=8.6u
X_FILL3_25_p VDD GND VDD VDD PMOS w=21.2u l=8.6u
X_FILL3_25_n GND VDD GND GND NMOS w=13.1u l=8.6u
X_FILL3_26_p VDD GND VDD VDD PMOS w=21.2u l=8.6u
X_FILL3_26_n GND VDD GND GND NMOS w=13.1u l=8.6u
X_FILL3_27_p VDD GND VDD VDD PMOS w=21.2u l=8.6u
X_FILL3_27_n GND VDD GND GND NMOS w=13.1u l=8.6u
X_FILL3_28_p VDD GND VDD VDD PMOS w=21.2u l=8.6u
X_FILL3_28_n GND VDD GND GND NMOS w=13.1u l=8.6u
X_FILL3_29_p VDD GND VDD VDD PMOS w=21.2u l=8.6u
X_FILL3_29_n GND VDD GND GND NMOS w=13.1u l=8.6u
X_FILL3_30_p VDD GND VDD VDD PMOS w=21.2u l=8.6u
X_FILL3_30_n GND VDD GND GND NMOS w=13.1u l=8.6u
X_FILL3_31_p VDD GND VDD VDD PMOS w=21.2u l=8.6u
X_FILL3_31_n GND VDD GND GND NMOS w=13.1u l=8.6u
X_FILL3_32_p VDD GND VDD VDD PMOS w=21.2u l=8.6u
X_FILL3_32_n GND VDD GND GND NMOS w=13.1u l=8.6u
X_FILL3_33_p VDD GND VDD VDD PMOS w=21.2u l=8.6u
X_FILL3_33_n GND VDD GND GND NMOS w=13.1u l=8.6u
X_FILL3_34_p VDD GND VDD VDD PMOS w=21.2u l=8.6u
X_FILL3_34_n GND VDD GND GND NMOS w=13.1u l=8.6u
X_FILL3_35_p VDD GND VDD VDD PMOS w=21.2u l=8.6u
X_FILL3_35_n GND VDD GND GND NMOS w=13.1u l=8.6u
X_FILL3_36_p VDD GND VDD VDD PMOS w=21.2u l=8.6u
X_FILL3_36_n GND VDD GND GND NMOS w=13.1u l=8.6u
X_FILL3_37_p VDD GND VDD VDD PMOS w=21.2u l=8.6u
X_FILL3_37_n GND VDD GND GND NMOS w=13.1u l=8.6u
X_FILL3_38_p VDD GND VDD VDD PMOS w=21.2u l=8.6u
X_FILL3_38_n GND VDD GND GND NMOS w=13.1u l=8.6u
X_FILL3_39_p VDD GND VDD VDD PMOS w=21.2u l=8.6u
X_FILL3_39_n GND VDD GND GND NMOS w=13.1u l=8.6u
X_FILL3_40_p VDD GND VDD VDD PMOS w=21.2u l=8.6u
X_FILL3_40_n GND VDD GND GND NMOS w=13.1u l=8.6u
X_FILL3_41_p VDD GND VDD VDD PMOS w=21.2u l=8.6u
X_FILL3_41_n GND VDD GND GND NMOS w=13.1u l=8.6u
X_FILL3_42_p VDD GND VDD VDD PMOS w=21.2u l=8.6u
X_FILL3_42_n GND VDD GND GND NMOS w=13.1u l=8.6u
X_FILL3_43_p VDD GND VDD VDD PMOS w=21.2u l=8.6u
X_FILL3_43_n GND VDD GND GND NMOS w=13.1u l=8.6u
X_FILL3_44_p VDD GND VDD VDD PMOS w=21.2u l=8.6u
X_FILL3_44_n GND VDD GND GND NMOS w=13.1u l=8.6u
X_FILL3_45_p VDD GND VDD VDD PMOS w=21.2u l=8.6u
X_FILL3_45_n GND VDD GND GND NMOS w=13.1u l=8.6u
X_FILL3_46_p VDD GND VDD VDD PMOS w=21.2u l=8.6u
X_FILL3_46_n GND VDD GND GND NMOS w=13.1u l=8.6u
X_FILL3_47_p VDD GND VDD VDD PMOS w=21.2u l=8.6u
X_FILL3_47_n GND VDD GND GND NMOS w=13.1u l=8.6u
X_FILL3_48_p VDD GND VDD VDD PMOS w=21.2u l=8.6u
X_FILL3_48_n GND VDD GND GND NMOS w=13.1u l=8.6u
X_FILL3_49_p VDD GND VDD VDD PMOS w=21.2u l=8.6u
X_FILL3_49_n GND VDD GND GND NMOS w=13.1u l=8.6u
X_FILL3_50_p VDD GND VDD VDD PMOS w=21.2u l=8.6u
X_FILL3_50_n GND VDD GND GND NMOS w=13.1u l=8.6u
X_FILL3_51_p VDD GND VDD VDD PMOS w=21.2u l=8.6u
X_FILL3_51_n GND VDD GND GND NMOS w=13.1u l=8.6u
X_FILL3_52_p VDD GND VDD VDD PMOS w=21.2u l=8.6u
X_FILL3_52_n GND VDD GND GND NMOS w=13.1u l=8.6u
X_FILL3_53_p VDD GND VDD VDD PMOS w=21.2u l=8.6u
X_FILL3_53_n GND VDD GND GND NMOS w=13.1u l=8.6u
X_FILL3_54_p VDD GND VDD VDD PMOS w=21.2u l=8.6u
X_FILL3_54_n GND VDD GND GND NMOS w=13.1u l=8.6u
X_FILL3_55_p VDD GND VDD VDD PMOS w=21.2u l=8.6u
X_FILL3_55_n GND VDD GND GND NMOS w=13.1u l=8.6u
X_FILL3_56_p VDD GND VDD VDD PMOS w=21.2u l=8.6u
X_FILL3_56_n GND VDD GND GND NMOS w=13.1u l=8.6u
X_FILL3_57_p VDD GND VDD VDD PMOS w=21.2u l=8.6u
X_FILL3_57_n GND VDD GND GND NMOS w=13.1u l=8.6u
X_FILL3_58_p VDD GND VDD VDD PMOS w=21.2u l=8.6u
X_FILL3_58_n GND VDD GND GND NMOS w=13.1u l=8.6u
X_FILL3_59_p VDD GND VDD VDD PMOS w=21.2u l=8.6u
X_FILL3_59_n GND VDD GND GND NMOS w=13.1u l=8.6u
X_FILL3_60_p VDD GND VDD VDD PMOS w=21.2u l=8.6u
X_FILL3_60_n GND VDD GND GND NMOS w=13.1u l=8.6u
X_FILL3_61_p VDD GND VDD VDD PMOS w=21.2u l=8.6u
X_FILL3_61_n GND VDD GND GND NMOS w=13.1u l=8.6u
X_FILL3_62_p VDD GND VDD VDD PMOS w=21.2u l=8.6u
X_FILL3_62_n GND VDD GND GND NMOS w=13.1u l=8.6u
X_FILL3_63_p VDD GND VDD VDD PMOS w=21.2u l=8.6u
X_FILL3_63_n GND VDD GND GND NMOS w=13.1u l=8.6u
X_FILL3_64_p VDD GND VDD VDD PMOS w=21.2u l=8.6u
X_FILL3_64_n GND VDD GND GND NMOS w=13.1u l=8.6u
X_FILL3_65_p VDD GND VDD VDD PMOS w=21.2u l=8.6u
X_FILL3_65_n GND VDD GND GND NMOS w=13.1u l=8.6u
X_FILL3_66_p VDD GND VDD VDD PMOS w=21.2u l=8.6u
X_FILL3_66_n GND VDD GND GND NMOS w=13.1u l=8.6u
X_FILL3_67_p VDD GND VDD VDD PMOS w=21.2u l=8.6u
X_FILL3_67_n GND VDD GND GND NMOS w=13.1u l=8.6u
X_FILL3_68_p VDD GND VDD VDD PMOS w=21.2u l=8.6u
X_FILL3_68_n GND VDD GND GND NMOS w=13.1u l=8.6u
X_FILL3_69_p VDD GND VDD VDD PMOS w=21.2u l=8.6u
X_FILL3_69_n GND VDD GND GND NMOS w=13.1u l=8.6u
X_FILL3_70_p VDD GND VDD VDD PMOS w=21.2u l=8.6u
X_FILL3_70_n GND VDD GND GND NMOS w=13.1u l=8.6u
X_FILL3_71_p VDD GND VDD VDD PMOS w=21.2u l=8.6u
X_FILL3_71_n GND VDD GND GND NMOS w=13.1u l=8.6u
X_FILL3_72_p VDD GND VDD VDD PMOS w=21.2u l=8.6u
X_FILL3_72_n GND VDD GND GND NMOS w=13.1u l=8.6u
X_FILL3_73_p VDD GND VDD VDD PMOS w=21.2u l=8.6u
X_FILL3_73_n GND VDD GND GND NMOS w=13.1u l=8.6u
X_FILL3_74_p VDD GND VDD VDD PMOS w=21.2u l=8.6u
X_FILL3_74_n GND VDD GND GND NMOS w=13.1u l=8.6u
X_FILL3_75_p VDD GND VDD VDD PMOS w=21.2u l=8.6u
X_FILL3_75_n GND VDD GND GND NMOS w=13.1u l=8.6u
X_FILL3_76_p VDD GND VDD VDD PMOS w=21.2u l=8.6u
X_FILL3_76_n GND VDD GND GND NMOS w=13.1u l=8.6u
X_FILL3_77_p VDD GND VDD VDD PMOS w=21.2u l=8.6u
X_FILL3_77_n GND VDD GND GND NMOS w=13.1u l=8.6u
X_FILL3_78_p VDD GND VDD VDD PMOS w=21.2u l=8.6u
X_FILL3_78_n GND VDD GND GND NMOS w=13.1u l=8.6u
X_FILL3_79_p VDD GND VDD VDD PMOS w=21.2u l=8.6u
X_FILL3_79_n GND VDD GND GND NMOS w=13.1u l=8.6u
X_FILL3_80_p VDD GND VDD VDD PMOS w=21.2u l=8.6u
X_FILL3_80_n GND VDD GND GND NMOS w=13.1u l=8.6u
X_FILL3_81_p VDD GND VDD VDD PMOS w=21.2u l=8.6u
X_FILL3_81_n GND VDD GND GND NMOS w=13.1u l=8.6u
X_FILL3_82_p VDD GND VDD VDD PMOS w=21.2u l=8.6u
X_FILL3_82_n GND VDD GND GND NMOS w=13.1u l=8.6u
X_FILL3_83_p VDD GND VDD VDD PMOS w=21.2u l=8.6u
X_FILL3_83_n GND VDD GND GND NMOS w=13.1u l=8.6u
.ends

.subckt FILL2 VDD GND
*.PININFO GND:B VDD:B
XM7 VDD GND VDD VDD PMOS w=21.2u l=3.2u
XM2 GND VDD GND GND NMOS w=13.1u l=3.2u
.ends

** sch_path: /Users/okamura/Dropbox/91_OpenPDK/TR-1um/libs.tech/xschem/IP62_5_stdcell/AND2_X1.sch
.subckt AND2_X1 VDD Y A B GND
*.PININFO Y:O A:I B:I VDD:B GND:B
XM7 net1 B VDD VDD PMOS w=10.2u l=1u
XM1 net1 A VDD VDD PMOS w=10.2u l=1u
XM2 Y net1 VDD VDD PMOS w=10.2u l=1u
XM3 Y net1 GND GND NMOS w=3.4u l=1u
XM4 net1 A net2 GND NMOS w=3.4u l=1u
XM5 net2 B GND GND NMOS w=3.4u l=1u
.ends

** sch_path: /Users/okamura/Dropbox/91_OpenPDK/TR-1um/libs.tech/xschem/IP62_5_stdcell/AND4_X1.sch
.subckt AND4_X1 D C VDD Y A B GND
*.PININFO Y:O A:I B:I VDD:B GND:B C:I D:I
XM7 net1 A net4 GND NMOS w=3.4u l=1u
XM5 net3 C net2 GND NMOS w=3.4u l=1u
XM8 Y net1 GND GND NMOS w=3.4u l=1u
XM10 net2 D GND GND NMOS w=3.4u l=1u
XM6 net4 B net3 GND NMOS w=3.4u l=1u
XM11 net1 A VDD VDD PMOS w=10.2u l=1u
XM1 net1 D VDD VDD PMOS w=10.2u l=1u
XM3 net1 C VDD VDD PMOS w=10.2u l=1u
XM4 Y net1 VDD VDD PMOS w=10.2u l=1u
XM2 net1 B VDD VDD PMOS w=10.2u l=1u
.ends

** sch_path: /Users/okamura/Dropbox/98_LSI_Design/TR-1um_Async_I2C/LEF/BUFTH.sch
.subckt BUFTH VDD A Y GND
*.PININFO A:I Y:O VDD:B GND:B
XM9 MID A net1 VDD PMOS w=5.1u l=1u
XM2 Y MID VDD VDD PMOS w=10.2u l=1u
XM8 MID A net2 GND NMOS w=3.4u l=1u
XM1 Y MID GND GND NMOS w=3.4u l=1u
XM6 GND MID net1 VDD PMOS w=10.2u l=1u
XM3 VDD MID net2 GND NMOS w=6.8u l=1u
XM5 net2 A GND GND NMOS w=3.4u l=1u
XM4 net1 A VDD VDD PMOS w=5.1u l=1u
.ends

** sch_path: /Users/okamura/Dropbox/91_OpenPDK/TR-1um/libs.tech/xschem/IP62_5_stdcell/BUF_X1.sch
.subckt BUF_X1 VDD A Y GND
*.PININFO A:I Y:O VDD:B GND:B
XM7 net1 A VDD VDD PMOS w=10.2u l=1u
XM1 Y net1 VDD VDD PMOS w=10.2u l=1u
XM3 net1 A GND GND NMOS w=3.4u l=1u
XM2 Y net1 GND GND NMOS w=3.4u l=1u
.ends

** sch_path: /Users/okamura/Dropbox/98_LSI_Design/TR-1um_Async_I2C/LEF/DFFRB.sch
.subckt DFFRB VDD QB D Q RSTB GND CK
*.PININFO VDD:B GND:B D:I QB:O CK:I Q:O RSTB:I
XM2 net1 D VDD VDD PMOS w=5.2u l=1u
XM1 net2 CKP net1 VDD PMOS w=5.2u l=1u
XM7 net2 CKB net3 GND NMOS w=3.4u l=1u
XM8 net3 D GND GND NMOS w=3.4u l=1u
XM10 QM net2 VDD VDD PMOS w=5.2u l=1u
XM11 QM net2 GND GND NMOS w=3.4u l=1u
XM13 net4 QM GND GND NMOS w=3.4u l=1u
XM15 net4 CKP net2 GND NMOS w=3.4u l=1u
XM22 QB QS VDD VDD PMOS w=10.4u l=1u
XM3 net4 QM VDD VDD PMOS w=5.2u l=1u
XM4 net2 CKB net4 VDD PMOS w=5.2u l=1u
XM5 QS CKP QM GND NMOS w=3.4u l=1u
XM6 QM CKB QS VDD PMOS w=5.2u l=1u
XM9 net5 QB GND GND NMOS w=3.4u l=1u
XM12 net5 QB VDD VDD PMOS w=5.2u l=1u
XM14 net5 CKB QS GND NMOS w=3.4u l=1u
XM16 QS CKP net5 VDD PMOS w=5.2u l=1u
XM17 QB RSTB net6 GND NMOS w=3.4u l=1u
XM18 Q QB VDD VDD PMOS w=10.4u l=1u
XM19 Q QB GND GND NMOS w=3.4u l=1u
XM20 CKB CK VDD VDD PMOS w=10.4u l=1u
XM21 CKB CK GND GND NMOS w=3.4u l=1u
XM23 CKP CKB VDD VDD PMOS w=10.4u l=1u
XM24 CKP CKB GND GND NMOS w=3.4u l=1u
XM25 net6 QS GND GND NMOS w=3.4u l=1u
XM26 QB RSTB VDD VDD PMOS w=10.4u l=1u
.ends

.subckt INV_X1 VDD A Y GND
*.PININFO A:I Y:O GND:B VDD:B
XM7 Y A VDD VDD PMOS w=10.2u l=1u
XM2 Y A GND GND NMOS w=3.4u l=1u
.ends

** sch_path: /Users/okamura/Dropbox/91_OpenPDK/TR-1um/libs.tech/xschem/IP62_5_stdcell/MUX2.sch
.subckt MUX2 A B S VDD Y GND
*.PININFO S:I Y:O VDD:B GND:B B:I A:I
XM13 SB S VDD VDD PMOS w=6.8u l=1u
XM8 net2 S net3 VDD PMOS w=6.8u l=1u
XM12 SB S GND GND NMOS w=3.4u l=1u
XM6 net2 SB net3 GND NMOS w=3.4u l=1u
XM11 net1 B VDD VDD PMOS w=6.8u l=1u
XM14 net1 B GND GND NMOS w=3.4u l=1u
XM15 net2 A VDD VDD PMOS w=6.8u l=1u
XM16 net2 A GND GND NMOS w=3.4u l=1u
XM3 net1 SB net3 VDD PMOS w=6.8u l=1u
XM5 net1 S net3 GND NMOS w=3.4u l=1u
XM1 Y net3 VDD VDD PMOS w=11.2u l=1u
XM2 Y net3 GND GND NMOS w=3.4u l=1u
.ends

.subckt MUXDFFRB VDD A Q B CK S QB VSS RSTB
*.PININFO A:I B:I CK:I Q:O QB:O VDD:B VSS:B S:I RSTB:I
Xx1_MM2 x1_net1 net1 VDD VDD PMOS w=5.2u l=1u
Xx1_MM1 x1_net2 x1_CKP x1_net1 VDD PMOS w=5.2u l=1u
Xx1_MM7 x1_net2 x1_CKB x1_net3 VSS NMOS w=3.4u l=1u
Xx1_MM8 x1_net3 net1 VSS VSS NMOS w=3.4u l=1u
Xx1_MM10 x1_QM x1_net2 VDD VDD PMOS w=5.2u l=1u
Xx1_MM11 x1_QM x1_net2 VSS VSS NMOS w=3.4u l=1u
Xx1_MM13 x1_net4 x1_QM VSS VSS NMOS w=3.4u l=1u
Xx1_MM15 x1_net4 x1_CKP x1_net2 VSS NMOS w=3.4u l=1u
Xx1_MM22 QB x1_QS VDD VDD PMOS w=10.4u l=1u
Xx1_MM3 x1_net4 x1_QM VDD VDD PMOS w=5.2u l=1u
Xx1_MM4 x1_net2 x1_CKB x1_net4 VDD PMOS w=5.2u l=1u
Xx1_MM5 x1_QS x1_CKP x1_QM VSS NMOS w=3.4u l=1u
Xx1_MM6 x1_QM x1_CKB x1_QS VDD PMOS w=5.2u l=1u
Xx1_MM9 x1_net5 QB VSS VSS NMOS w=3.4u l=1u
Xx1_MM12 x1_net5 QB VDD VDD PMOS w=5.2u l=1u
Xx1_MM14 x1_net5 x1_CKB x1_QS VSS NMOS w=3.4u l=1u
Xx1_MM16 x1_QS x1_CKP x1_net5 VDD PMOS w=5.2u l=1u
Xx1_MM17 QB RSTB x1_net6 VSS NMOS w=3.4u l=1u
Xx1_MM18 Q QB VDD VDD PMOS w=10.4u l=1u
Xx1_MM19 Q QB VSS VSS NMOS w=3.4u l=1u
Xx1_MM20 x1_CKB CK VDD VDD PMOS w=10.4u l=1u
Xx1_MM21 x1_CKB CK VSS VSS NMOS w=3.4u l=1u
Xx1_MM23 x1_CKP x1_CKB VDD VDD PMOS w=10.4u l=1u
Xx1_MM24 x1_CKP x1_CKB VSS VSS NMOS w=3.4u l=1u
Xx1_MM25 x1_net6 x1_QS VSS VSS NMOS w=3.4u l=1u
Xx1_MM26 QB RSTB VDD VDD PMOS w=10.4u l=1u
Xx2_MM13 x2_SB S VDD VDD PMOS w=6.8u l=1u
Xx2_MM8 x2_net2 S x2_net3 VDD PMOS w=6.8u l=1u
Xx2_MM12 x2_SB S VSS VSS NMOS w=3.4u l=1u
Xx2_MM6 x2_net2 x2_SB x2_net3 VSS NMOS w=3.4u l=1u
Xx2_MM11 x2_net1 B VDD VDD PMOS w=6.8u l=1u
Xx2_MM14 x2_net1 B VSS VSS NMOS w=3.4u l=1u
Xx2_MM15 x2_net2 A VDD VDD PMOS w=6.8u l=1u
Xx2_MM16 x2_net2 A VSS VSS NMOS w=3.4u l=1u
Xx2_MM3 x2_net1 x2_SB x2_net3 VDD PMOS w=6.8u l=1u
Xx2_MM5 x2_net1 S x2_net3 VSS NMOS w=3.4u l=1u
Xx2_MM1 net1 x2_net3 VDD VDD PMOS w=11.2u l=1u
Xx2_MM2 net1 x2_net3 VSS VSS NMOS w=3.4u l=1u
.ends

** sch_path: /Users/okamura/Dropbox/91_OpenPDK/TR-1um/libs.tech/xschem/IP62_5_stdcell/NAND2.sch
.subckt NAND2 VDD Y A B GND
*.PININFO B:I A:I Y:O GND:B VDD:B
XM7 Y A VDD VDD PMOS w=10.2u l=1u
XM1 Y B VDD VDD PMOS w=10.2u l=1u
XM2 Y B net1 GND NMOS w=3.4u l=1u
XM3 net1 A GND GND NMOS w=3.4u l=1u
.ends

** sch_path: /Users/okamura/Dropbox/91_OpenPDK/TR-1um/libs.tech/xschem/IP62_5_stdcell/NAND3.sch
.subckt NAND3 C VDD Y A B GND
*.PININFO B:I A:I Y:O GND:B VDD:B C:I
XM1 Y A VDD VDD PMOS w=10.2u l=1u
XM4 Y B VDD VDD PMOS w=10.2u l=1u
XM6 Y C VDD VDD PMOS w=10.2u l=1u
XM7 Y C net1 GND NMOS w=3.4u l=1u
XM2 net1 B net2 GND NMOS w=3.4u l=1u
XM3 net2 A GND GND NMOS w=3.4u l=1u
.ends

** sch_path: /Users/okamura/Dropbox/91_OpenPDK/TR-1um/libs.tech/xschem/IP62_5_stdcell/NOR2.sch
.subckt NOR2 VDD Y A B GND
*.PININFO A:I B:I Y:O VDD:B GND:B
XM7 net1 A VDD VDD PMOS w=10.2u l=1u
XM1 Y B net1 VDD PMOS w=10.2u l=1u
XM2 Y A GND GND NMOS w=3.4u l=1u
XM3 Y B GND GND NMOS w=3.4u l=1u
.ends

** sch_path: /Users/okamura/Dropbox/91_OpenPDK/TR-1um/libs.tech/xschem/IP62_5_stdcell/NOR3.sch
.subckt NOR3 B C VDD Y A GND
*.PININFO A:I B:I Y:O VDD:B GND:B C:I
XM7 net1 B VDD VDD PMOS w=10.2u l=1u
XM2 net2 A net1 VDD PMOS w=10.2u l=1u
XM3 Y C net2 VDD PMOS w=10.2u l=1u
XM1 Y B GND GND NMOS w=3.4u l=1u
XM4 Y C GND GND NMOS w=3.4u l=1u
XM5 Y A GND GND NMOS w=3.4u l=1u
.ends

** sch_path: /Users/okamura/Dropbox/91_OpenPDK/TR-1um/libs.tech/xschem/IP62_5_stdcell/NOR4.sch
.subckt NOR4 A B C D VDD Y GND
*.PININFO A:I B:I Y:O VDD:B GND:B C:I D:I
XM8 net1 B VDD VDD PMOS w=10.2u l=1u
XM2 net2 A net1 VDD PMOS w=10.2u l=1u
XM3 net3 C net2 VDD PMOS w=10.2u l=1u
XM6 Y D net3 VDD PMOS w=10.2u l=1u
XM9 Y D GND GND NMOS w=3.4u l=1u
XM1 Y B GND GND NMOS w=3.4u l=1u
XM4 Y C GND GND NMOS w=3.4u l=1u
XM5 Y A GND GND NMOS w=3.4u l=1u
.ends

** sch_path: /Users/okamura/Dropbox/91_OpenPDK/TR-1um/libs.tech/xschem/IP62_5_stdcell/OR2.sch
.subckt OR2 VDD Y A B GND
*.PININFO A:I B:I Y:O VDD:B GND:B
XM7 net2 B VDD VDD PMOS w=10.2u l=1u
XM2 net1 A net2 VDD PMOS w=10.2u l=1u
XM4 Y net1 VDD VDD PMOS w=10.2u l=1u
XM1 net1 B GND GND NMOS w=3.4u l=1u
XM3 net1 A GND GND NMOS w=3.4u l=1u
XM5 Y net1 GND GND NMOS w=3.4u l=1u
.ends

** sch_path: /Users/okamura/Dropbox/91_OpenPDK/TR-1um/libs.tech/xschem/IP62_5_stdcell/OR3.sch
.subckt OR3 C VDD Y A B GND
*.PININFO A:I B:I Y:O VDD:B GND:B C:I
XM8 net1 B VDD VDD PMOS w=10.2u l=1u
XM2 net2 A net1 VDD PMOS w=10.2u l=1u
XM3 net3 C net2 VDD PMOS w=10.2u l=1u
XM7 Y net3 VDD VDD PMOS w=10.2u l=1u
XM9 Y net3 GND GND NMOS w=3.4u l=1u
XM1 net3 C GND GND NMOS w=3.4u l=1u
XM4 net3 A GND GND NMOS w=3.4u l=1u
XM5 net3 B GND GND NMOS w=3.4u l=1u
.ends

** sch_path: /Users/okamura/Dropbox/91_OpenPDK/TR-1um/libs.tech/xschem/IP62_5_stdcell/OR4.sch
.subckt OR4 A B C D VDD Y GND
*.PININFO B:I A:I Y:O VDD:B GND:B C:I D:I
XM10 net1 B VDD VDD PMOS w=10.2u l=1u
XM2 net2 A net1 VDD PMOS w=10.2u l=1u
XM3 net4 C net2 VDD PMOS w=10.2u l=1u
XM7 Y net3 VDD VDD PMOS w=10.2u l=1u
XM9 net4 D net3 VDD PMOS w=10.2u l=1u
XM11 net3 A GND GND NMOS w=3.4u l=1u
XM1 net3 B GND GND NMOS w=3.4u l=1u
XM4 net3 C GND GND NMOS w=3.4u l=1u
XM5 net3 D GND GND NMOS w=3.4u l=1u
XM6 Y net3 GND GND NMOS w=3.4u l=1u
.ends

.subckt RSLATCH VDD S Q R QB VSS
*.PININFO R:I S:I Q:O QB:O VDD:B VSS:B
Xx1_MM7 x1_net1 R VDD VDD PMOS w=10.2u l=1u
Xx1_MM1 Q QB x1_net1 VDD PMOS w=10.2u l=1u
Xx1_MM2 Q R VSS VSS NMOS w=3.4u l=1u
Xx1_MM3 Q QB VSS VSS NMOS w=3.4u l=1u
Xx2_MM7 x2_net1 S VDD VDD PMOS w=10.2u l=1u
Xx2_MM1 QB Q x2_net1 VDD PMOS w=10.2u l=1u
Xx2_MM2 QB S VSS VSS NMOS w=3.4u l=1u
Xx2_MM3 QB Q VSS VSS NMOS w=3.4u l=1u
.ends

** sch_path: /Users/okamura/Dropbox/98_LSI_Design/TR-1um_Async_I2C/LEF/XNOR2.sch
.subckt XNOR2 VDD Y A B GND
*.PININFO VDD:B GND:B A:I B:I Y:O
XM10 net1 A VDD VDD PMOS w=10.2u l=1u
XM1 net1 B VDD VDD PMOS w=10.2u l=1u
XM2 Y net1 VDD VDD PMOS w=10.2u l=1u
XM3 net4 B VDD VDD PMOS w=10.2u l=1u
XM4 Y A net4 VDD PMOS w=10.2u l=1u
XM11 net1 B net3 GND NMOS w=3.4u l=1u
XM5 net3 A GND GND NMOS w=3.4u l=1u
XM6 Y net1 net2 GND NMOS w=3.4u l=1u
XM7 net2 A GND GND NMOS w=3.4u l=1u
XM8 net2 B GND GND NMOS w=3.4u l=1u
.ends

** sch_path: /Users/okamura/Dropbox/98_LSI_Design/TR-1um_Async_I2C/LEF/XOR2.sch
.subckt XOR2 VDD Y A B GND
*.PININFO VDD:B GND:B A:I B:I Y:O
XM10 net1 A VDD VDD PMOS w=10.2u l=1u
XM1 net2 B net1 VDD PMOS w=10.2u l=1u
XM8 net3 A VDD VDD PMOS w=10.2u l=1u
XM2 net3 B VDD VDD PMOS w=10.2u l=1u
XM9 Y net2 net3 VDD PMOS w=10.2u l=1u
XM3 net2 A GND GND NMOS w=3.4u l=1u
XM4 net2 B GND GND NMOS w=3.4u l=1u
XM5 Y net2 GND GND NMOS w=3.4u l=1u
XM7 net4 B GND GND NMOS w=3.4u l=1u
XM6 Y A net4 GND NMOS w=3.4u l=1u
.ends

.subckt tr_1um_i2c_slave_async P1 P2 P3 P4 P5 P6 P7 VSS P9 P10 P11 P12 P13 P14 P15 VDD
x1 P1 VDD P2 P15 P14 P3 P4 P13
+ P5 P12 P6 P11 P10 P7 P9 VSS
+ VDD NC_HIZ2 VSS VSS P7 P7 P7 P7
+ P7 P7 P7 P7 VDD VDD NC_OUT1 VSS
+ NC_OUT9 NC_OUT10 NC_OUT3 NC_OUT4 NC_OUT11 NC_OUT5 NC_OUT12 NC_OUT6
+ NC_OUT13 NC_OUT14 NC_OUT7 NC_OUT15 OSS_FRAME_GIO
x2 P15 P1 P2 P4 P12 P14 P5 P6
+ P3 P11 P13 NC_HIZ2 NC_OUT4 NC_OUT12 NC_OUT14 NC_OUT5
+ NC_OUT6 NC_OUT3 NC_OUT11 NC_OUT13 NC_CORE_rx_valid NC_CORE_addr_match NC_CORE_rw NC_CORE_busy
+ VDD VSS i2c_slave_async_nrow_fm
.ends
