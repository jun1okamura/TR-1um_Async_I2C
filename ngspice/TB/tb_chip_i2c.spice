* tb_chip_i2c.spice -- auto-generated by script/gen_chip_tb_v9.py
* DO NOT hand-edit -- regenerate instead.
*
* Whole-chip (RING_OSC excluded) I2C WRITE-then-READ testbench at
* SCL=100kHz, using the real TR-1um transistor models (same ip62_models
* include already confirmed working for RING_OSC's own ngspice
* testbench, script/gen_ring_osc_tb.py) and ngspice/tr_1um_i2c_slave_
* async_sim_ready.spice (the LVS-confirmed chip netlist, M->X + NMOSE->
* MNE converted -- see script/gen_chip_sim_ready_v9.py).
*
* Protocol (mirrors script/test_i2c_slave_async.py's own bus-functional
* model exactly -- same SLAVE_ADDR/DATA values/bit order/ACK convention,
* just re-timed to a clean 100kHz clock instead of that model's
* arbitrary-T relative timing):
*   WRITE: S, ADDR+W(0xA0), ACK, DATA=0xA5, ACK, P
*   READ : S, ADDR+R(0xA1), ACK, DATA=0x3C (slave-driven), NACK, P
*
* DIS (P7) held HIGH the whole run (Hi-Z / tx_data-input mode) so the 8
* shared tx/rx pads never contend with this testbench's own TX drive --
* rx_data is instead observed at each pad's own internal receiver net
* (NC_OUT.. ), which reflects the pad regardless of DIS (see this
* script's own module docstring, and gen_irsim_cmd_v9.py's identical
* convention). tx_data is held at 0x3C for the whole run (only
* consumed during the read).

.include '~/Dropbox/91_OpenPDK/TR-1um/libs.tech/spice/models/ip62_models'
.include '../tr_1um_i2c_slave_async_sim_ready.spice'

.param vdd=5.0

vvdd VDD 0 DC 5.0
vvss VSS 0 DC 0

* RSTN: low for 500ns (power-on reset), then a fast edge to VDD,
* held for the rest of the run -- real async reset via each DFFRB's own
* RSTB pin (no IRSIM-style QM/QS force needed; that was an IRSIM
* switch-level-solver-only workaround, see this script's own docstring).
vrstn P15 0 PWL(0 0 5e-07 0 6e-07 5.0)

* DIS: held high the whole run (see docstring).
vdis P7 0 DC 5.0

* P9/P10 (RING_OSC.OUTD/OUT in the full chip -- unused and otherwise
* floating here, since RING_OSC is excluded from this netlist). Tied to
* VSS via a large resistor purely for SPICE DC-path/convergence safety
* (each pad's own internal ESD diode already provides some finite
* leakage path to VSS, but an explicit high-value tie avoids relying on
* that for the operating-point solve).
rp9 P9 VSS 1G
rp10 P10 VSS 1G

* tx_data (bit0..7 = ['P11', 'P12', 'P13', 'P14', 'P6', 'P5', 'P4', 'P3']), held at 0x3C for the whole run.
vtx0 P11 0 DC 0.0
vtx1 P12 0 DC 0.0
vtx2 P13 0 DC 5.0
vtx3 P14 0 DC 5.0
vtx4 P6 0 DC 5.0
vtx5 P5 0 DC 5.0
vtx6 P4 0 DC 0.0
vtx7 P3 0 DC 0.0

* SCL: master clock, 100kHz during bus activity (idle high otherwise).
vscl P1 0 PWL(0 5.000 2e-06 5.000 1.19e-05 5.000 1.2e-05 0.000 1.69e-05 0.000 1.7e-05 5.000 2.19e-05 5.000 2.2e-05 0.000 2.69e-05 0.000 2.7e-05 5.000 3.19e-05 5.000 3.2e-05 0.000 3.69e-05 0.000 3.7e-05 5.000 4.19e-05 5.000 4.2e-05 0.000 4.69e-05 0.000 4.7e-05 5.000 5.19e-05 5.000 5.2e-05 0.000 5.69e-05 0.000 5.7e-05 5.000 6.19e-05 5.000 6.2e-05 0.000 6.69e-05 0.000 6.7e-05 5.000 7.19e-05 5.000 7.2e-05 0.000 7.69e-05 0.000 7.7e-05 5.000 8.19e-05 5.000 8.2e-05 0.000 8.69e-05 0.000 8.7e-05 5.000 9.19e-05 5.000 9.2e-05 0.000 9.69e-05 0.000 9.7e-05 5.000 0.0001019 5.000 0.000102 0.000 0.0001069 0.000 0.000107 5.000 0.0001119 5.000 0.000112 0.000 0.0001169 0.000 0.000117 5.000 0.0001219 5.000 0.000122 0.000 0.0001269 0.000 0.000127 5.000 0.0001319 5.000 0.000132 0.000 0.0001369 0.000 0.000137 5.000 0.0001419 5.000 0.000142 0.000 0.0001469 0.000 0.000147 5.000 0.0001519 5.000 0.000152 0.000 0.0001569 0.000 0.000157 5.000 0.0001619 5.000 0.000162 0.000 0.0001669 0.000 0.000167 5.000 0.0001719 5.000 0.000172 0.000 0.0001769 0.000 0.000177 5.000 0.0001819 5.000 0.000182 0.000 0.0001869 0.000 0.000187 5.000 0.0001919 5.000 0.000192 0.000 0.0001969 0.000 0.000197 5.000 0.000207 5.000 0.000212 5.000 0.0002219 5.000 0.000222 0.000 0.0002269 0.000 0.000227 5.000 0.0002319 5.000 0.000232 0.000 0.0002369 0.000 0.000237 5.000 0.0002419 5.000 0.000242 0.000 0.0002469 0.000 0.000247 5.000 0.0002519 5.000 0.000252 0.000 0.0002569 0.000 0.000257 5.000 0.0002619 5.000 0.000262 0.000 0.0002669 0.000 0.000267 5.000 0.0002719 5.000 0.000272 0.000 0.0002769 0.000 0.000277 5.000 0.0002819 5.000 0.000282 0.000 0.0002869 0.000 0.000287 5.000 0.0002919 5.000 0.000292 0.000 0.0002969 0.000 0.000297 5.000 0.0003019 5.000 0.000302 0.000 0.0003069 0.000 0.000307 5.000 0.0003119 5.000 0.000312 0.000 0.0003169 0.000 0.000317 5.000 0.0003219 5.000 0.000322 0.000 0.0003269 0.000 0.000327 5.000 0.0003319 5.000 0.000332 0.000 0.0003369 0.000 0.000337 5.000 0.0003419 5.000 0.000342 0.000 0.0003469 0.000 0.000347 5.000 0.0003519 5.000 0.000352 0.000 0.0003569 0.000 0.000357 5.000 0.0003619 5.000 0.000362 0.000 0.0003669 0.000 0.000367 5.000 0.0003719 5.000 0.000372 0.000 0.0003769 0.000 0.000377 5.000 0.0003819 5.000 0.000382 0.000 0.0003869 0.000 0.000387 5.000 0.0003919 5.000 0.000392 0.000 0.0003969 0.000 0.000397 5.000 0.0004019 5.000 0.000402 0.000 0.0004069 0.000 0.000407 5.000 0.000417 5.000 0.000422 5.000)

* SDA open-drain bus: this testbench's own master drive (voltage-
* controlled switch to VSS, gated by SDA_CTRL) in parallel with an
* external 10k pull-up to VDD (per user instruction -- the chip
* itself has no on-chip SDA pull-up, design_notes.md 76.29-76.38) and
* the DUT's own internal SDA driver (already part of the DUT netlist).
vsda_ctrl SDA_CTRL 0 PWL(0 0.000 2e-06 0.000 6.9e-06 0.000 7e-06 5.000 1.22e-05 5.000 1.23e-05 0.000 2.22e-05 0.000 2.23e-05 5.000 3.22e-05 5.000 3.23e-05 0.000 4.22e-05 0.000 4.23e-05 5.000 5.23e-05 5.000 6.23e-05 5.000 7.23e-05 5.000 8.23e-05 5.000 9.22e-05 5.000 9.23e-05 0.000 0.0001023 0.000 0.0001122 0.000 0.0001123 5.000 0.0001222 5.000 0.0001223 0.000 0.0001322 0.000 0.0001323 5.000 0.0001423 5.000 0.0001522 5.000 0.0001523 0.000 0.0001622 0.000 0.0001623 5.000 0.0001722 5.000 0.0001723 0.000 0.0001823 0.000 0.0001922 0.000 0.0001923 5.000 0.0002019 5.000 0.000202 0.000 0.000207 0.000 0.000212 0.000 0.0002169 0.000 0.000217 5.000 0.0002222 5.000 0.0002223 0.000 0.0002322 0.000 0.0002323 5.000 0.0002422 5.000 0.0002423 0.000 0.0002522 0.000 0.0002523 5.000 0.0002623 5.000 0.0002723 5.000 0.0002823 5.000 0.0002922 5.000 0.0002923 0.000 0.0003023 0.000 0.0003123 0.000 0.0003223 0.000 0.0003323 0.000 0.0003423 0.000 0.0003523 0.000 0.0003623 0.000 0.0003723 0.000 0.0003823 0.000 0.0003923 0.000 0.0004022 0.000 0.0004023 5.000 0.0004119 5.000 0.000412 0.000 0.000417 0.000 0.000422 0.000)
.model SDASW SW(RON=10 ROFF=1MEG VT=2.5 VH=0.3)
ssda P2 0 SDA_CTRL 0 SDASW
rpu P2 VDD 10k

* DUT instantiation -- pin order read directly from ngspice/tr_1um_i2c_
* slave_async_sim_ready.spice's own '.subckt tr_1um_i2c_slave_async ...'
* line (not hand-typed), see read_top_pin_order().
xdut P1 P2 P3 P4 P5 P6 P7 VSS P9 P10 P11 P12 P13 P14 P15 VDD tr_1um_i2c_slave_async

.tran 50n 0.000424

* ---- sample points: read-data bits (mid SCL-high window of each of
* the 8 slave-driven bits during the read transaction) ----
.measure tran rd_bit0 FIND v(P2) AT=0.0003195  $ expect ~0V (bit=0)
.measure tran rd_bit1 FIND v(P2) AT=0.0003295  $ expect ~0V (bit=0)
.measure tran rd_bit2 FIND v(P2) AT=0.0003395  $ expect ~VDD (bit=1)
.measure tran rd_bit3 FIND v(P2) AT=0.0003495  $ expect ~VDD (bit=1)
.measure tran rd_bit4 FIND v(P2) AT=0.0003595  $ expect ~VDD (bit=1)
.measure tran rd_bit5 FIND v(P2) AT=0.0003695  $ expect ~VDD (bit=1)
.measure tran rd_bit6 FIND v(P2) AT=0.0003795  $ expect ~0V (bit=0)
.measure tran rd_bit7 FIND v(P2) AT=0.0003895  $ expect ~0V (bit=0)

* ---- ACK sample points (expect ~0V = ACK asserted) ----
.measure tran ack0 FIND v(P2) AT=9.95e-05  $ ACK (slave, address/write)
.measure tran ack1 FIND v(P2) AT=0.0001895  $ ACK (slave, data)
.measure tran ack2 FIND v(P2) AT=0.0003095  $ ACK (slave, address/read)
.measure tran ack3 FIND v(P2) AT=0.0003995  $ NACK (master, ends read)

* ---- diagnostic: internal core state (busy/addr_match/rw), to
* localize a non-responsive-bus result -- see gen_chip_tb_v9.py's own
* module docstring / build_tb() comment for why these were added ----
.measure tran busy_after_start FIND v(xdut.NC_CORE_busy) AT=9.5e-06  $ expect ~VDD (busy asserted shortly after START)
.measure tran addr_match_write FIND v(xdut.NC_CORE_addr_match) AT=0.0001018  $ expect ~VDD if address 0x50 matched (ACK (slave, address/write))
.measure tran rw_write FIND v(xdut.NC_CORE_rw) AT=0.0001018  $ expect ~0V (write)
.measure tran addr_match_write_x1 WHEN v(xdut.NC_CORE_addr_match)=2.5 RISE=1  $ addr_match rise #1 (ACK (slave, address/write))
.measure tran addr_match_read FIND v(xdut.NC_CORE_addr_match) AT=0.0003118  $ expect ~VDD if address 0x50 matched (ACK (slave, address/read))
.measure tran rw_read FIND v(xdut.NC_CORE_rw) AT=0.0003118  $ expect ~VDD (read)
.measure tran addr_match_read_x1 WHEN v(xdut.NC_CORE_addr_match)=2.5 RISE=2  $ addr_match rise #2 (ACK (slave, address/read))

* ---- diagnostic: this generator's OWN driven bus level self-check
* (independent of the DUT) for every master-driven address/data bit ----
.measure tran tx_ADDR_W_bit7 FIND v(P2) AT=1.95e-05  $ self-check: this generator's OWN driven bus level, ADDR+W bit7 (expect ~VDD (bit=1))
.measure tran tx_ADDR_W_bit6 FIND v(P2) AT=2.95e-05  $ self-check: this generator's OWN driven bus level, ADDR+W bit6 (expect ~0V (bit=0))
.measure tran tx_ADDR_W_bit5 FIND v(P2) AT=3.95e-05  $ self-check: this generator's OWN driven bus level, ADDR+W bit5 (expect ~VDD (bit=1))
.measure tran tx_ADDR_W_bit4 FIND v(P2) AT=4.95e-05  $ self-check: this generator's OWN driven bus level, ADDR+W bit4 (expect ~0V (bit=0))
.measure tran tx_ADDR_W_bit3 FIND v(P2) AT=5.95e-05  $ self-check: this generator's OWN driven bus level, ADDR+W bit3 (expect ~0V (bit=0))
.measure tran tx_ADDR_W_bit2 FIND v(P2) AT=6.95e-05  $ self-check: this generator's OWN driven bus level, ADDR+W bit2 (expect ~0V (bit=0))
.measure tran tx_ADDR_W_bit1 FIND v(P2) AT=7.95e-05  $ self-check: this generator's OWN driven bus level, ADDR+W bit1 (expect ~0V (bit=0))
.measure tran tx_ADDR_W_bit0 FIND v(P2) AT=8.95e-05  $ self-check: this generator's OWN driven bus level, ADDR+W bit0 (expect ~0V (bit=0))
.measure tran tx_DATA_write_bit7 FIND v(P2) AT=0.0001095  $ self-check: this generator's OWN driven bus level, DATA (write) bit7 (expect ~VDD (bit=1))
.measure tran tx_DATA_write_bit6 FIND v(P2) AT=0.0001195  $ self-check: this generator's OWN driven bus level, DATA (write) bit6 (expect ~0V (bit=0))
.measure tran tx_DATA_write_bit5 FIND v(P2) AT=0.0001295  $ self-check: this generator's OWN driven bus level, DATA (write) bit5 (expect ~VDD (bit=1))
.measure tran tx_DATA_write_bit4 FIND v(P2) AT=0.0001395  $ self-check: this generator's OWN driven bus level, DATA (write) bit4 (expect ~0V (bit=0))
.measure tran tx_DATA_write_bit3 FIND v(P2) AT=0.0001495  $ self-check: this generator's OWN driven bus level, DATA (write) bit3 (expect ~0V (bit=0))
.measure tran tx_DATA_write_bit2 FIND v(P2) AT=0.0001595  $ self-check: this generator's OWN driven bus level, DATA (write) bit2 (expect ~VDD (bit=1))
.measure tran tx_DATA_write_bit1 FIND v(P2) AT=0.0001695  $ self-check: this generator's OWN driven bus level, DATA (write) bit1 (expect ~0V (bit=0))
.measure tran tx_DATA_write_bit0 FIND v(P2) AT=0.0001795  $ self-check: this generator's OWN driven bus level, DATA (write) bit0 (expect ~VDD (bit=1))
.measure tran tx_ADDR_R_bit7 FIND v(P2) AT=0.0002295  $ self-check: this generator's OWN driven bus level, ADDR+R bit7 (expect ~VDD (bit=1))
.measure tran tx_ADDR_R_bit6 FIND v(P2) AT=0.0002395  $ self-check: this generator's OWN driven bus level, ADDR+R bit6 (expect ~0V (bit=0))
.measure tran tx_ADDR_R_bit5 FIND v(P2) AT=0.0002495  $ self-check: this generator's OWN driven bus level, ADDR+R bit5 (expect ~VDD (bit=1))
.measure tran tx_ADDR_R_bit4 FIND v(P2) AT=0.0002595  $ self-check: this generator's OWN driven bus level, ADDR+R bit4 (expect ~0V (bit=0))
.measure tran tx_ADDR_R_bit3 FIND v(P2) AT=0.0002695  $ self-check: this generator's OWN driven bus level, ADDR+R bit3 (expect ~0V (bit=0))
.measure tran tx_ADDR_R_bit2 FIND v(P2) AT=0.0002795  $ self-check: this generator's OWN driven bus level, ADDR+R bit2 (expect ~0V (bit=0))
.measure tran tx_ADDR_R_bit1 FIND v(P2) AT=0.0002895  $ self-check: this generator's OWN driven bus level, ADDR+R bit1 (expect ~0V (bit=0))
.measure tran tx_ADDR_R_bit0 FIND v(P2) AT=0.0002995  $ self-check: this generator's OWN driven bus level, ADDR+R bit0 (expect ~VDD (bit=1))

* ---- diagnostic: internal address shift-register (shreg_0..shreg_6,
* inside xdut.x2 = i2c_slave_async_nrow_fm) snapshot right after each
* address byte's last-bit SCL edge ----
.measure tran shreg_0_write FIND v(xdut.x2.shreg_0) AT=8.9e-05  $ internal address shift-reg bit, right after the ADDR+W last-bit SCL edge
.measure tran shreg_1_write FIND v(xdut.x2.shreg_1) AT=8.9e-05  $ internal address shift-reg bit, right after the ADDR+W last-bit SCL edge
.measure tran shreg_2_write FIND v(xdut.x2.shreg_2) AT=8.9e-05  $ internal address shift-reg bit, right after the ADDR+W last-bit SCL edge
.measure tran shreg_3_write FIND v(xdut.x2.shreg_3) AT=8.9e-05  $ internal address shift-reg bit, right after the ADDR+W last-bit SCL edge
.measure tran shreg_4_write FIND v(xdut.x2.shreg_4) AT=8.9e-05  $ internal address shift-reg bit, right after the ADDR+W last-bit SCL edge
.measure tran shreg_5_write FIND v(xdut.x2.shreg_5) AT=8.9e-05  $ internal address shift-reg bit, right after the ADDR+W last-bit SCL edge
.measure tran shreg_6_write FIND v(xdut.x2.shreg_6) AT=8.9e-05  $ internal address shift-reg bit, right after the ADDR+W last-bit SCL edge
.measure tran shreg_0_read FIND v(xdut.x2.shreg_0) AT=0.000299  $ internal address shift-reg bit, right after the ADDR+R last-bit SCL edge
.measure tran shreg_1_read FIND v(xdut.x2.shreg_1) AT=0.000299  $ internal address shift-reg bit, right after the ADDR+R last-bit SCL edge
.measure tran shreg_2_read FIND v(xdut.x2.shreg_2) AT=0.000299  $ internal address shift-reg bit, right after the ADDR+R last-bit SCL edge
.measure tran shreg_3_read FIND v(xdut.x2.shreg_3) AT=0.000299  $ internal address shift-reg bit, right after the ADDR+R last-bit SCL edge
.measure tran shreg_4_read FIND v(xdut.x2.shreg_4) AT=0.000299  $ internal address shift-reg bit, right after the ADDR+R last-bit SCL edge
.measure tran shreg_5_read FIND v(xdut.x2.shreg_5) AT=0.000299  $ internal address shift-reg bit, right after the ADDR+R last-bit SCL edge
.measure tran shreg_6_read FIND v(xdut.x2.shreg_6) AT=0.000299  $ internal address shift-reg bit, right after the ADDR+R last-bit SCL edge

* ---- diagnostic: clock-tree (scl_row0 vs scl_row1) and phase-FSM
* (phase_0/1/2, x2-internal addr_match/rw) probes ----
.measure tran phase0_after_start FIND v(xdut.x2.phase_0) AT=9.5e-06  $ phase bit0 shortly after START
.measure tran phase1_after_start FIND v(xdut.x2.phase_1) AT=9.5e-06  $ phase bit1 shortly after START
.measure tran phase2_after_start FIND v(xdut.x2.phase_2) AT=9.5e-06  $ phase bit2 shortly after START
.measure tran bit_cnt_0_at_start_begin FIND v(xdut.x2.bit_cnt_0) AT=2.001e-06  $ bit_cnt_0 at_start_begin
.measure tran bit_cnt_1_at_start_begin FIND v(xdut.x2.bit_cnt_1) AT=2.001e-06  $ bit_cnt_1 at_start_begin
.measure tran bit_cnt_2_at_start_begin FIND v(xdut.x2.bit_cnt_2) AT=2.001e-06  $ bit_cnt_2 at_start_begin
.measure tran lbp_at_start_begin FIND v(xdut.x2.last_bit_pending) AT=2.001e-06  $ last_bit_pending at_start_begin
.measure tran bit_cnt_0_before_bit7_edge FIND v(xdut.x2.bit_cnt_0) AT=1.22e-05  $ bit_cnt_0 before_bit7_edge
.measure tran bit_cnt_1_before_bit7_edge FIND v(xdut.x2.bit_cnt_1) AT=1.22e-05  $ bit_cnt_1 before_bit7_edge
.measure tran bit_cnt_2_before_bit7_edge FIND v(xdut.x2.bit_cnt_2) AT=1.22e-05  $ bit_cnt_2 before_bit7_edge
.measure tran lbp_before_bit7_edge FIND v(xdut.x2.last_bit_pending) AT=1.22e-05  $ last_bit_pending before_bit7_edge
.measure tran bit_cnt_0_rst_300n FIND v(xdut.x2.bit_cnt_0) AT=3e-07  $ bit_cnt_0 at rst_300n
.measure tran phase_0_rst_300n FIND v(xdut.x2.phase_0) AT=3e-07  $ phase_0 at rst_300n (for comparison -- resets correctly per earlier probes)
.measure tran bit_cnt_0_rst_550n FIND v(xdut.x2.bit_cnt_0) AT=5.5e-07  $ bit_cnt_0 at rst_550n
.measure tran phase_0_rst_550n FIND v(xdut.x2.phase_0) AT=5.5e-07  $ phase_0 at rst_550n (for comparison -- resets correctly per earlier probes)
.measure tran bit_cnt_0_rst_650n FIND v(xdut.x2.bit_cnt_0) AT=6.5e-07  $ bit_cnt_0 at rst_650n
.measure tran phase_0_rst_650n FIND v(xdut.x2.phase_0) AT=6.5e-07  $ phase_0 at rst_650n (for comparison -- resets correctly per earlier probes)
.measure tran bit_cnt_0_rst_900n FIND v(xdut.x2.bit_cnt_0) AT=9e-07  $ bit_cnt_0 at rst_900n
.measure tran phase_0_rst_900n FIND v(xdut.x2.phase_0) AT=9e-07  $ phase_0 at rst_900n (for comparison -- resets correctly per earlier probes)
.measure tran bit_cnt_0_rst_1200n FIND v(xdut.x2.bit_cnt_0) AT=1.2e-06  $ bit_cnt_0 at rst_1200n
.measure tran phase_0_rst_1200n FIND v(xdut.x2.phase_0) AT=1.2e-06  $ phase_0 at rst_1200n (for comparison -- resets correctly per earlier probes)
.measure tran bit_cnt_0_rst_1600n FIND v(xdut.x2.bit_cnt_0) AT=1.6e-06  $ bit_cnt_0 at rst_1600n
.measure tran phase_0_rst_1600n FIND v(xdut.x2.phase_0) AT=1.6e-06  $ phase_0 at rst_1600n (for comparison -- resets correctly per earlier probes)
.measure tran fine_bitcnt0_t0 FIND v(xdut.x2.bit_cnt_0) AT=1.75e-05  $ bit_cnt_0 fine sweep point 0 (17.5us)
.measure tran fine_ck_t0 FIND v(xdut.x2._156__row1) AT=1.75e-05  $ _156__row1 (shared clock net) fine sweep point 0 (17.5us)
.measure tran fine_rstb_t0 FIND v(xdut.x2._016_) AT=1.75e-05  $ _016_ (RSTB, shared by write-addr critical group) fine sweep point 0 (17.5us)
.measure tran fine_held_t0 FIND v(xdut.x2.rst_scl_domain_held) AT=1.75e-05  $ rst_scl_domain_held fine sweep point 0 (17.5us)
.measure tran fine_qn_t0 FIND v(xdut.x2.rst_stretch_qn) AT=1.75e-05  $ rst_stretch_qn fine sweep point 0 (17.5us)
.measure tran fine_raw_t0 FIND v(xdut.x2._143_) AT=1.75e-05  $ _143_ (rst_scl_domain_raw) fine sweep point 0 (17.5us)
.measure tran fine_clr_t0 FIND v(xdut.x2._144_) AT=1.75e-05  $ _144_ (rst_stretch_clr) fine sweep point 0 (17.5us)
.measure tran fine_d_t0 FIND v(xdut.x2._066_) AT=1.75e-05  $ _066_ (D input to bit_cnt_0's flop) fine sweep point 0 (17.5us)
.measure tran fine_qb_t0 FIND v(xdut.x2._212_) AT=1.75e-05  $ _212_ (QB output of bit_cnt_0's flop) fine sweep point 0 (17.5us)
.measure tran fine_qm_t0 FIND v(xdut.x2.x_505_.qm) AT=1.75e-05  $ internal QM (master latch out) of x_505_ fine sweep point 0 (17.5us)
.measure tran fine_net2_t0 FIND v(xdut.x2.x_505_.net2) AT=1.75e-05  $ internal net2 (master dynamic node) of x_505_ fine sweep point 0 (17.5us)
.measure tran fine_qs_t0 FIND v(xdut.x2.x_505_.qs) AT=1.75e-05  $ internal QS (slave latch out) of x_505_ fine sweep point 0 (17.5us)
.measure tran fine_net5_t0 FIND v(xdut.x2.x_505_.net5) AT=1.75e-05  $ internal net5 (slave dynamic node) of x_505_ fine sweep point 0 (17.5us)
.measure tran fine_bitcnt0_t1 FIND v(xdut.x2.bit_cnt_0) AT=1.85e-05  $ bit_cnt_0 fine sweep point 1 (18.5us)
.measure tran fine_ck_t1 FIND v(xdut.x2._156__row1) AT=1.85e-05  $ _156__row1 (shared clock net) fine sweep point 1 (18.5us)
.measure tran fine_rstb_t1 FIND v(xdut.x2._016_) AT=1.85e-05  $ _016_ (RSTB, shared by write-addr critical group) fine sweep point 1 (18.5us)
.measure tran fine_held_t1 FIND v(xdut.x2.rst_scl_domain_held) AT=1.85e-05  $ rst_scl_domain_held fine sweep point 1 (18.5us)
.measure tran fine_qn_t1 FIND v(xdut.x2.rst_stretch_qn) AT=1.85e-05  $ rst_stretch_qn fine sweep point 1 (18.5us)
.measure tran fine_raw_t1 FIND v(xdut.x2._143_) AT=1.85e-05  $ _143_ (rst_scl_domain_raw) fine sweep point 1 (18.5us)
.measure tran fine_clr_t1 FIND v(xdut.x2._144_) AT=1.85e-05  $ _144_ (rst_stretch_clr) fine sweep point 1 (18.5us)
.measure tran fine_d_t1 FIND v(xdut.x2._066_) AT=1.85e-05  $ _066_ (D input to bit_cnt_0's flop) fine sweep point 1 (18.5us)
.measure tran fine_qb_t1 FIND v(xdut.x2._212_) AT=1.85e-05  $ _212_ (QB output of bit_cnt_0's flop) fine sweep point 1 (18.5us)
.measure tran fine_qm_t1 FIND v(xdut.x2.x_505_.qm) AT=1.85e-05  $ internal QM (master latch out) of x_505_ fine sweep point 1 (18.5us)
.measure tran fine_net2_t1 FIND v(xdut.x2.x_505_.net2) AT=1.85e-05  $ internal net2 (master dynamic node) of x_505_ fine sweep point 1 (18.5us)
.measure tran fine_qs_t1 FIND v(xdut.x2.x_505_.qs) AT=1.85e-05  $ internal QS (slave latch out) of x_505_ fine sweep point 1 (18.5us)
.measure tran fine_net5_t1 FIND v(xdut.x2.x_505_.net5) AT=1.85e-05  $ internal net5 (slave dynamic node) of x_505_ fine sweep point 1 (18.5us)
.measure tran fine_bitcnt0_t2 FIND v(xdut.x2.bit_cnt_0) AT=1.95e-05  $ bit_cnt_0 fine sweep point 2 (19.5us)
.measure tran fine_ck_t2 FIND v(xdut.x2._156__row1) AT=1.95e-05  $ _156__row1 (shared clock net) fine sweep point 2 (19.5us)
.measure tran fine_rstb_t2 FIND v(xdut.x2._016_) AT=1.95e-05  $ _016_ (RSTB, shared by write-addr critical group) fine sweep point 2 (19.5us)
.measure tran fine_held_t2 FIND v(xdut.x2.rst_scl_domain_held) AT=1.95e-05  $ rst_scl_domain_held fine sweep point 2 (19.5us)
.measure tran fine_qn_t2 FIND v(xdut.x2.rst_stretch_qn) AT=1.95e-05  $ rst_stretch_qn fine sweep point 2 (19.5us)
.measure tran fine_raw_t2 FIND v(xdut.x2._143_) AT=1.95e-05  $ _143_ (rst_scl_domain_raw) fine sweep point 2 (19.5us)
.measure tran fine_clr_t2 FIND v(xdut.x2._144_) AT=1.95e-05  $ _144_ (rst_stretch_clr) fine sweep point 2 (19.5us)
.measure tran fine_d_t2 FIND v(xdut.x2._066_) AT=1.95e-05  $ _066_ (D input to bit_cnt_0's flop) fine sweep point 2 (19.5us)
.measure tran fine_qb_t2 FIND v(xdut.x2._212_) AT=1.95e-05  $ _212_ (QB output of bit_cnt_0's flop) fine sweep point 2 (19.5us)
.measure tran fine_qm_t2 FIND v(xdut.x2.x_505_.qm) AT=1.95e-05  $ internal QM (master latch out) of x_505_ fine sweep point 2 (19.5us)
.measure tran fine_net2_t2 FIND v(xdut.x2.x_505_.net2) AT=1.95e-05  $ internal net2 (master dynamic node) of x_505_ fine sweep point 2 (19.5us)
.measure tran fine_qs_t2 FIND v(xdut.x2.x_505_.qs) AT=1.95e-05  $ internal QS (slave latch out) of x_505_ fine sweep point 2 (19.5us)
.measure tran fine_net5_t2 FIND v(xdut.x2.x_505_.net5) AT=1.95e-05  $ internal net5 (slave dynamic node) of x_505_ fine sweep point 2 (19.5us)
.measure tran fine_bitcnt0_t3 FIND v(xdut.x2.bit_cnt_0) AT=2.05e-05  $ bit_cnt_0 fine sweep point 3 (20.5us)
.measure tran fine_ck_t3 FIND v(xdut.x2._156__row1) AT=2.05e-05  $ _156__row1 (shared clock net) fine sweep point 3 (20.5us)
.measure tran fine_rstb_t3 FIND v(xdut.x2._016_) AT=2.05e-05  $ _016_ (RSTB, shared by write-addr critical group) fine sweep point 3 (20.5us)
.measure tran fine_held_t3 FIND v(xdut.x2.rst_scl_domain_held) AT=2.05e-05  $ rst_scl_domain_held fine sweep point 3 (20.5us)
.measure tran fine_qn_t3 FIND v(xdut.x2.rst_stretch_qn) AT=2.05e-05  $ rst_stretch_qn fine sweep point 3 (20.5us)
.measure tran fine_raw_t3 FIND v(xdut.x2._143_) AT=2.05e-05  $ _143_ (rst_scl_domain_raw) fine sweep point 3 (20.5us)
.measure tran fine_clr_t3 FIND v(xdut.x2._144_) AT=2.05e-05  $ _144_ (rst_stretch_clr) fine sweep point 3 (20.5us)
.measure tran fine_d_t3 FIND v(xdut.x2._066_) AT=2.05e-05  $ _066_ (D input to bit_cnt_0's flop) fine sweep point 3 (20.5us)
.measure tran fine_qb_t3 FIND v(xdut.x2._212_) AT=2.05e-05  $ _212_ (QB output of bit_cnt_0's flop) fine sweep point 3 (20.5us)
.measure tran fine_qm_t3 FIND v(xdut.x2.x_505_.qm) AT=2.05e-05  $ internal QM (master latch out) of x_505_ fine sweep point 3 (20.5us)
.measure tran fine_net2_t3 FIND v(xdut.x2.x_505_.net2) AT=2.05e-05  $ internal net2 (master dynamic node) of x_505_ fine sweep point 3 (20.5us)
.measure tran fine_qs_t3 FIND v(xdut.x2.x_505_.qs) AT=2.05e-05  $ internal QS (slave latch out) of x_505_ fine sweep point 3 (20.5us)
.measure tran fine_net5_t3 FIND v(xdut.x2.x_505_.net5) AT=2.05e-05  $ internal net5 (slave dynamic node) of x_505_ fine sweep point 3 (20.5us)
.measure tran fine_bitcnt0_t4 FIND v(xdut.x2.bit_cnt_0) AT=2.15e-05  $ bit_cnt_0 fine sweep point 4 (21.5us)
.measure tran fine_ck_t4 FIND v(xdut.x2._156__row1) AT=2.15e-05  $ _156__row1 (shared clock net) fine sweep point 4 (21.5us)
.measure tran fine_rstb_t4 FIND v(xdut.x2._016_) AT=2.15e-05  $ _016_ (RSTB, shared by write-addr critical group) fine sweep point 4 (21.5us)
.measure tran fine_held_t4 FIND v(xdut.x2.rst_scl_domain_held) AT=2.15e-05  $ rst_scl_domain_held fine sweep point 4 (21.5us)
.measure tran fine_qn_t4 FIND v(xdut.x2.rst_stretch_qn) AT=2.15e-05  $ rst_stretch_qn fine sweep point 4 (21.5us)
.measure tran fine_raw_t4 FIND v(xdut.x2._143_) AT=2.15e-05  $ _143_ (rst_scl_domain_raw) fine sweep point 4 (21.5us)
.measure tran fine_clr_t4 FIND v(xdut.x2._144_) AT=2.15e-05  $ _144_ (rst_stretch_clr) fine sweep point 4 (21.5us)
.measure tran fine_d_t4 FIND v(xdut.x2._066_) AT=2.15e-05  $ _066_ (D input to bit_cnt_0's flop) fine sweep point 4 (21.5us)
.measure tran fine_qb_t4 FIND v(xdut.x2._212_) AT=2.15e-05  $ _212_ (QB output of bit_cnt_0's flop) fine sweep point 4 (21.5us)
.measure tran fine_qm_t4 FIND v(xdut.x2.x_505_.qm) AT=2.15e-05  $ internal QM (master latch out) of x_505_ fine sweep point 4 (21.5us)
.measure tran fine_net2_t4 FIND v(xdut.x2.x_505_.net2) AT=2.15e-05  $ internal net2 (master dynamic node) of x_505_ fine sweep point 4 (21.5us)
.measure tran fine_qs_t4 FIND v(xdut.x2.x_505_.qs) AT=2.15e-05  $ internal QS (slave latch out) of x_505_ fine sweep point 4 (21.5us)
.measure tran fine_net5_t4 FIND v(xdut.x2.x_505_.net5) AT=2.15e-05  $ internal net5 (slave dynamic node) of x_505_ fine sweep point 4 (21.5us)
.measure tran fine_bitcnt0_t5 FIND v(xdut.x2.bit_cnt_0) AT=2.25e-05  $ bit_cnt_0 fine sweep point 5 (22.5us)
.measure tran fine_ck_t5 FIND v(xdut.x2._156__row1) AT=2.25e-05  $ _156__row1 (shared clock net) fine sweep point 5 (22.5us)
.measure tran fine_rstb_t5 FIND v(xdut.x2._016_) AT=2.25e-05  $ _016_ (RSTB, shared by write-addr critical group) fine sweep point 5 (22.5us)
.measure tran fine_held_t5 FIND v(xdut.x2.rst_scl_domain_held) AT=2.25e-05  $ rst_scl_domain_held fine sweep point 5 (22.5us)
.measure tran fine_qn_t5 FIND v(xdut.x2.rst_stretch_qn) AT=2.25e-05  $ rst_stretch_qn fine sweep point 5 (22.5us)
.measure tran fine_raw_t5 FIND v(xdut.x2._143_) AT=2.25e-05  $ _143_ (rst_scl_domain_raw) fine sweep point 5 (22.5us)
.measure tran fine_clr_t5 FIND v(xdut.x2._144_) AT=2.25e-05  $ _144_ (rst_stretch_clr) fine sweep point 5 (22.5us)
.measure tran fine_d_t5 FIND v(xdut.x2._066_) AT=2.25e-05  $ _066_ (D input to bit_cnt_0's flop) fine sweep point 5 (22.5us)
.measure tran fine_qb_t5 FIND v(xdut.x2._212_) AT=2.25e-05  $ _212_ (QB output of bit_cnt_0's flop) fine sweep point 5 (22.5us)
.measure tran fine_qm_t5 FIND v(xdut.x2.x_505_.qm) AT=2.25e-05  $ internal QM (master latch out) of x_505_ fine sweep point 5 (22.5us)
.measure tran fine_net2_t5 FIND v(xdut.x2.x_505_.net2) AT=2.25e-05  $ internal net2 (master dynamic node) of x_505_ fine sweep point 5 (22.5us)
.measure tran fine_qs_t5 FIND v(xdut.x2.x_505_.qs) AT=2.25e-05  $ internal QS (slave latch out) of x_505_ fine sweep point 5 (22.5us)
.measure tran fine_net5_t5 FIND v(xdut.x2.x_505_.net5) AT=2.25e-05  $ internal net5 (slave dynamic node) of x_505_ fine sweep point 5 (22.5us)
.measure tran fine_bitcnt0_t6 FIND v(xdut.x2.bit_cnt_0) AT=2.35e-05  $ bit_cnt_0 fine sweep point 6 (23.5us)
.measure tran fine_ck_t6 FIND v(xdut.x2._156__row1) AT=2.35e-05  $ _156__row1 (shared clock net) fine sweep point 6 (23.5us)
.measure tran fine_rstb_t6 FIND v(xdut.x2._016_) AT=2.35e-05  $ _016_ (RSTB, shared by write-addr critical group) fine sweep point 6 (23.5us)
.measure tran fine_held_t6 FIND v(xdut.x2.rst_scl_domain_held) AT=2.35e-05  $ rst_scl_domain_held fine sweep point 6 (23.5us)
.measure tran fine_qn_t6 FIND v(xdut.x2.rst_stretch_qn) AT=2.35e-05  $ rst_stretch_qn fine sweep point 6 (23.5us)
.measure tran fine_raw_t6 FIND v(xdut.x2._143_) AT=2.35e-05  $ _143_ (rst_scl_domain_raw) fine sweep point 6 (23.5us)
.measure tran fine_clr_t6 FIND v(xdut.x2._144_) AT=2.35e-05  $ _144_ (rst_stretch_clr) fine sweep point 6 (23.5us)
.measure tran fine_d_t6 FIND v(xdut.x2._066_) AT=2.35e-05  $ _066_ (D input to bit_cnt_0's flop) fine sweep point 6 (23.5us)
.measure tran fine_qb_t6 FIND v(xdut.x2._212_) AT=2.35e-05  $ _212_ (QB output of bit_cnt_0's flop) fine sweep point 6 (23.5us)
.measure tran fine_qm_t6 FIND v(xdut.x2.x_505_.qm) AT=2.35e-05  $ internal QM (master latch out) of x_505_ fine sweep point 6 (23.5us)
.measure tran fine_net2_t6 FIND v(xdut.x2.x_505_.net2) AT=2.35e-05  $ internal net2 (master dynamic node) of x_505_ fine sweep point 6 (23.5us)
.measure tran fine_qs_t6 FIND v(xdut.x2.x_505_.qs) AT=2.35e-05  $ internal QS (slave latch out) of x_505_ fine sweep point 6 (23.5us)
.measure tran fine_net5_t6 FIND v(xdut.x2.x_505_.net5) AT=2.35e-05  $ internal net5 (slave dynamic node) of x_505_ fine sweep point 6 (23.5us)
.measure tran fine_bitcnt0_t7 FIND v(xdut.x2.bit_cnt_0) AT=2.45e-05  $ bit_cnt_0 fine sweep point 7 (24.5us)
.measure tran fine_ck_t7 FIND v(xdut.x2._156__row1) AT=2.45e-05  $ _156__row1 (shared clock net) fine sweep point 7 (24.5us)
.measure tran fine_rstb_t7 FIND v(xdut.x2._016_) AT=2.45e-05  $ _016_ (RSTB, shared by write-addr critical group) fine sweep point 7 (24.5us)
.measure tran fine_held_t7 FIND v(xdut.x2.rst_scl_domain_held) AT=2.45e-05  $ rst_scl_domain_held fine sweep point 7 (24.5us)
.measure tran fine_qn_t7 FIND v(xdut.x2.rst_stretch_qn) AT=2.45e-05  $ rst_stretch_qn fine sweep point 7 (24.5us)
.measure tran fine_raw_t7 FIND v(xdut.x2._143_) AT=2.45e-05  $ _143_ (rst_scl_domain_raw) fine sweep point 7 (24.5us)
.measure tran fine_clr_t7 FIND v(xdut.x2._144_) AT=2.45e-05  $ _144_ (rst_stretch_clr) fine sweep point 7 (24.5us)
.measure tran fine_d_t7 FIND v(xdut.x2._066_) AT=2.45e-05  $ _066_ (D input to bit_cnt_0's flop) fine sweep point 7 (24.5us)
.measure tran fine_qb_t7 FIND v(xdut.x2._212_) AT=2.45e-05  $ _212_ (QB output of bit_cnt_0's flop) fine sweep point 7 (24.5us)
.measure tran fine_qm_t7 FIND v(xdut.x2.x_505_.qm) AT=2.45e-05  $ internal QM (master latch out) of x_505_ fine sweep point 7 (24.5us)
.measure tran fine_net2_t7 FIND v(xdut.x2.x_505_.net2) AT=2.45e-05  $ internal net2 (master dynamic node) of x_505_ fine sweep point 7 (24.5us)
.measure tran fine_qs_t7 FIND v(xdut.x2.x_505_.qs) AT=2.45e-05  $ internal QS (slave latch out) of x_505_ fine sweep point 7 (24.5us)
.measure tran fine_net5_t7 FIND v(xdut.x2.x_505_.net5) AT=2.45e-05  $ internal net5 (slave dynamic node) of x_505_ fine sweep point 7 (24.5us)
.measure tran fine_bitcnt0_t8 FIND v(xdut.x2.bit_cnt_0) AT=2.55e-05  $ bit_cnt_0 fine sweep point 8 (25.5us)
.measure tran fine_ck_t8 FIND v(xdut.x2._156__row1) AT=2.55e-05  $ _156__row1 (shared clock net) fine sweep point 8 (25.5us)
.measure tran fine_rstb_t8 FIND v(xdut.x2._016_) AT=2.55e-05  $ _016_ (RSTB, shared by write-addr critical group) fine sweep point 8 (25.5us)
.measure tran fine_held_t8 FIND v(xdut.x2.rst_scl_domain_held) AT=2.55e-05  $ rst_scl_domain_held fine sweep point 8 (25.5us)
.measure tran fine_qn_t8 FIND v(xdut.x2.rst_stretch_qn) AT=2.55e-05  $ rst_stretch_qn fine sweep point 8 (25.5us)
.measure tran fine_raw_t8 FIND v(xdut.x2._143_) AT=2.55e-05  $ _143_ (rst_scl_domain_raw) fine sweep point 8 (25.5us)
.measure tran fine_clr_t8 FIND v(xdut.x2._144_) AT=2.55e-05  $ _144_ (rst_stretch_clr) fine sweep point 8 (25.5us)
.measure tran fine_d_t8 FIND v(xdut.x2._066_) AT=2.55e-05  $ _066_ (D input to bit_cnt_0's flop) fine sweep point 8 (25.5us)
.measure tran fine_qb_t8 FIND v(xdut.x2._212_) AT=2.55e-05  $ _212_ (QB output of bit_cnt_0's flop) fine sweep point 8 (25.5us)
.measure tran fine_qm_t8 FIND v(xdut.x2.x_505_.qm) AT=2.55e-05  $ internal QM (master latch out) of x_505_ fine sweep point 8 (25.5us)
.measure tran fine_net2_t8 FIND v(xdut.x2.x_505_.net2) AT=2.55e-05  $ internal net2 (master dynamic node) of x_505_ fine sweep point 8 (25.5us)
.measure tran fine_qs_t8 FIND v(xdut.x2.x_505_.qs) AT=2.55e-05  $ internal QS (slave latch out) of x_505_ fine sweep point 8 (25.5us)
.measure tran fine_net5_t8 FIND v(xdut.x2.x_505_.net5) AT=2.55e-05  $ internal net5 (slave dynamic node) of x_505_ fine sweep point 8 (25.5us)
.measure tran fine_bitcnt0_t9 FIND v(xdut.x2.bit_cnt_0) AT=2.65e-05  $ bit_cnt_0 fine sweep point 9 (26.5us)
.measure tran fine_ck_t9 FIND v(xdut.x2._156__row1) AT=2.65e-05  $ _156__row1 (shared clock net) fine sweep point 9 (26.5us)
.measure tran fine_rstb_t9 FIND v(xdut.x2._016_) AT=2.65e-05  $ _016_ (RSTB, shared by write-addr critical group) fine sweep point 9 (26.5us)
.measure tran fine_held_t9 FIND v(xdut.x2.rst_scl_domain_held) AT=2.65e-05  $ rst_scl_domain_held fine sweep point 9 (26.5us)
.measure tran fine_qn_t9 FIND v(xdut.x2.rst_stretch_qn) AT=2.65e-05  $ rst_stretch_qn fine sweep point 9 (26.5us)
.measure tran fine_raw_t9 FIND v(xdut.x2._143_) AT=2.65e-05  $ _143_ (rst_scl_domain_raw) fine sweep point 9 (26.5us)
.measure tran fine_clr_t9 FIND v(xdut.x2._144_) AT=2.65e-05  $ _144_ (rst_stretch_clr) fine sweep point 9 (26.5us)
.measure tran fine_d_t9 FIND v(xdut.x2._066_) AT=2.65e-05  $ _066_ (D input to bit_cnt_0's flop) fine sweep point 9 (26.5us)
.measure tran fine_qb_t9 FIND v(xdut.x2._212_) AT=2.65e-05  $ _212_ (QB output of bit_cnt_0's flop) fine sweep point 9 (26.5us)
.measure tran fine_qm_t9 FIND v(xdut.x2.x_505_.qm) AT=2.65e-05  $ internal QM (master latch out) of x_505_ fine sweep point 9 (26.5us)
.measure tran fine_net2_t9 FIND v(xdut.x2.x_505_.net2) AT=2.65e-05  $ internal net2 (master dynamic node) of x_505_ fine sweep point 9 (26.5us)
.measure tran fine_qs_t9 FIND v(xdut.x2.x_505_.qs) AT=2.65e-05  $ internal QS (slave latch out) of x_505_ fine sweep point 9 (26.5us)
.measure tran fine_net5_t9 FIND v(xdut.x2.x_505_.net5) AT=2.65e-05  $ internal net5 (slave dynamic node) of x_505_ fine sweep point 9 (26.5us)
.measure tran fine_bitcnt0_t10 FIND v(xdut.x2.bit_cnt_0) AT=2.75e-05  $ bit_cnt_0 fine sweep point 10 (27.5us)
.measure tran fine_ck_t10 FIND v(xdut.x2._156__row1) AT=2.75e-05  $ _156__row1 (shared clock net) fine sweep point 10 (27.5us)
.measure tran fine_rstb_t10 FIND v(xdut.x2._016_) AT=2.75e-05  $ _016_ (RSTB, shared by write-addr critical group) fine sweep point 10 (27.5us)
.measure tran fine_held_t10 FIND v(xdut.x2.rst_scl_domain_held) AT=2.75e-05  $ rst_scl_domain_held fine sweep point 10 (27.5us)
.measure tran fine_qn_t10 FIND v(xdut.x2.rst_stretch_qn) AT=2.75e-05  $ rst_stretch_qn fine sweep point 10 (27.5us)
.measure tran fine_raw_t10 FIND v(xdut.x2._143_) AT=2.75e-05  $ _143_ (rst_scl_domain_raw) fine sweep point 10 (27.5us)
.measure tran fine_clr_t10 FIND v(xdut.x2._144_) AT=2.75e-05  $ _144_ (rst_stretch_clr) fine sweep point 10 (27.5us)
.measure tran fine_d_t10 FIND v(xdut.x2._066_) AT=2.75e-05  $ _066_ (D input to bit_cnt_0's flop) fine sweep point 10 (27.5us)
.measure tran fine_qb_t10 FIND v(xdut.x2._212_) AT=2.75e-05  $ _212_ (QB output of bit_cnt_0's flop) fine sweep point 10 (27.5us)
.measure tran fine_qm_t10 FIND v(xdut.x2.x_505_.qm) AT=2.75e-05  $ internal QM (master latch out) of x_505_ fine sweep point 10 (27.5us)
.measure tran fine_net2_t10 FIND v(xdut.x2.x_505_.net2) AT=2.75e-05  $ internal net2 (master dynamic node) of x_505_ fine sweep point 10 (27.5us)
.measure tran fine_qs_t10 FIND v(xdut.x2.x_505_.qs) AT=2.75e-05  $ internal QS (slave latch out) of x_505_ fine sweep point 10 (27.5us)
.measure tran fine_net5_t10 FIND v(xdut.x2.x_505_.net5) AT=2.75e-05  $ internal net5 (slave dynamic node) of x_505_ fine sweep point 10 (27.5us)
.measure tran fine_bitcnt0_t11 FIND v(xdut.x2.bit_cnt_0) AT=2.85e-05  $ bit_cnt_0 fine sweep point 11 (28.5us)
.measure tran fine_ck_t11 FIND v(xdut.x2._156__row1) AT=2.85e-05  $ _156__row1 (shared clock net) fine sweep point 11 (28.5us)
.measure tran fine_rstb_t11 FIND v(xdut.x2._016_) AT=2.85e-05  $ _016_ (RSTB, shared by write-addr critical group) fine sweep point 11 (28.5us)
.measure tran fine_held_t11 FIND v(xdut.x2.rst_scl_domain_held) AT=2.85e-05  $ rst_scl_domain_held fine sweep point 11 (28.5us)
.measure tran fine_qn_t11 FIND v(xdut.x2.rst_stretch_qn) AT=2.85e-05  $ rst_stretch_qn fine sweep point 11 (28.5us)
.measure tran fine_raw_t11 FIND v(xdut.x2._143_) AT=2.85e-05  $ _143_ (rst_scl_domain_raw) fine sweep point 11 (28.5us)
.measure tran fine_clr_t11 FIND v(xdut.x2._144_) AT=2.85e-05  $ _144_ (rst_stretch_clr) fine sweep point 11 (28.5us)
.measure tran fine_d_t11 FIND v(xdut.x2._066_) AT=2.85e-05  $ _066_ (D input to bit_cnt_0's flop) fine sweep point 11 (28.5us)
.measure tran fine_qb_t11 FIND v(xdut.x2._212_) AT=2.85e-05  $ _212_ (QB output of bit_cnt_0's flop) fine sweep point 11 (28.5us)
.measure tran fine_qm_t11 FIND v(xdut.x2.x_505_.qm) AT=2.85e-05  $ internal QM (master latch out) of x_505_ fine sweep point 11 (28.5us)
.measure tran fine_net2_t11 FIND v(xdut.x2.x_505_.net2) AT=2.85e-05  $ internal net2 (master dynamic node) of x_505_ fine sweep point 11 (28.5us)
.measure tran fine_qs_t11 FIND v(xdut.x2.x_505_.qs) AT=2.85e-05  $ internal QS (slave latch out) of x_505_ fine sweep point 11 (28.5us)
.measure tran fine_net5_t11 FIND v(xdut.x2.x_505_.net5) AT=2.85e-05  $ internal net5 (slave dynamic node) of x_505_ fine sweep point 11 (28.5us)
.measure tran fine_bitcnt0_t12 FIND v(xdut.x2.bit_cnt_0) AT=2.95e-05  $ bit_cnt_0 fine sweep point 12 (29.5us)
.measure tran fine_ck_t12 FIND v(xdut.x2._156__row1) AT=2.95e-05  $ _156__row1 (shared clock net) fine sweep point 12 (29.5us)
.measure tran fine_rstb_t12 FIND v(xdut.x2._016_) AT=2.95e-05  $ _016_ (RSTB, shared by write-addr critical group) fine sweep point 12 (29.5us)
.measure tran fine_held_t12 FIND v(xdut.x2.rst_scl_domain_held) AT=2.95e-05  $ rst_scl_domain_held fine sweep point 12 (29.5us)
.measure tran fine_qn_t12 FIND v(xdut.x2.rst_stretch_qn) AT=2.95e-05  $ rst_stretch_qn fine sweep point 12 (29.5us)
.measure tran fine_raw_t12 FIND v(xdut.x2._143_) AT=2.95e-05  $ _143_ (rst_scl_domain_raw) fine sweep point 12 (29.5us)
.measure tran fine_clr_t12 FIND v(xdut.x2._144_) AT=2.95e-05  $ _144_ (rst_stretch_clr) fine sweep point 12 (29.5us)
.measure tran fine_d_t12 FIND v(xdut.x2._066_) AT=2.95e-05  $ _066_ (D input to bit_cnt_0's flop) fine sweep point 12 (29.5us)
.measure tran fine_qb_t12 FIND v(xdut.x2._212_) AT=2.95e-05  $ _212_ (QB output of bit_cnt_0's flop) fine sweep point 12 (29.5us)
.measure tran fine_qm_t12 FIND v(xdut.x2.x_505_.qm) AT=2.95e-05  $ internal QM (master latch out) of x_505_ fine sweep point 12 (29.5us)
.measure tran fine_net2_t12 FIND v(xdut.x2.x_505_.net2) AT=2.95e-05  $ internal net2 (master dynamic node) of x_505_ fine sweep point 12 (29.5us)
.measure tran fine_qs_t12 FIND v(xdut.x2.x_505_.qs) AT=2.95e-05  $ internal QS (slave latch out) of x_505_ fine sweep point 12 (29.5us)
.measure tran fine_net5_t12 FIND v(xdut.x2.x_505_.net5) AT=2.95e-05  $ internal net5 (slave dynamic node) of x_505_ fine sweep point 12 (29.5us)
.measure tran fine_bitcnt0_t13 FIND v(xdut.x2.bit_cnt_0) AT=3.05e-05  $ bit_cnt_0 fine sweep point 13 (30.5us)
.measure tran fine_ck_t13 FIND v(xdut.x2._156__row1) AT=3.05e-05  $ _156__row1 (shared clock net) fine sweep point 13 (30.5us)
.measure tran fine_rstb_t13 FIND v(xdut.x2._016_) AT=3.05e-05  $ _016_ (RSTB, shared by write-addr critical group) fine sweep point 13 (30.5us)
.measure tran fine_held_t13 FIND v(xdut.x2.rst_scl_domain_held) AT=3.05e-05  $ rst_scl_domain_held fine sweep point 13 (30.5us)
.measure tran fine_qn_t13 FIND v(xdut.x2.rst_stretch_qn) AT=3.05e-05  $ rst_stretch_qn fine sweep point 13 (30.5us)
.measure tran fine_raw_t13 FIND v(xdut.x2._143_) AT=3.05e-05  $ _143_ (rst_scl_domain_raw) fine sweep point 13 (30.5us)
.measure tran fine_clr_t13 FIND v(xdut.x2._144_) AT=3.05e-05  $ _144_ (rst_stretch_clr) fine sweep point 13 (30.5us)
.measure tran fine_d_t13 FIND v(xdut.x2._066_) AT=3.05e-05  $ _066_ (D input to bit_cnt_0's flop) fine sweep point 13 (30.5us)
.measure tran fine_qb_t13 FIND v(xdut.x2._212_) AT=3.05e-05  $ _212_ (QB output of bit_cnt_0's flop) fine sweep point 13 (30.5us)
.measure tran fine_qm_t13 FIND v(xdut.x2.x_505_.qm) AT=3.05e-05  $ internal QM (master latch out) of x_505_ fine sweep point 13 (30.5us)
.measure tran fine_net2_t13 FIND v(xdut.x2.x_505_.net2) AT=3.05e-05  $ internal net2 (master dynamic node) of x_505_ fine sweep point 13 (30.5us)
.measure tran fine_qs_t13 FIND v(xdut.x2.x_505_.qs) AT=3.05e-05  $ internal QS (slave latch out) of x_505_ fine sweep point 13 (30.5us)
.measure tran fine_net5_t13 FIND v(xdut.x2.x_505_.net5) AT=3.05e-05  $ internal net5 (slave dynamic node) of x_505_ fine sweep point 13 (30.5us)
.measure tran fine_bitcnt0_t14 FIND v(xdut.x2.bit_cnt_0) AT=3.15e-05  $ bit_cnt_0 fine sweep point 14 (31.5us)
.measure tran fine_ck_t14 FIND v(xdut.x2._156__row1) AT=3.15e-05  $ _156__row1 (shared clock net) fine sweep point 14 (31.5us)
.measure tran fine_rstb_t14 FIND v(xdut.x2._016_) AT=3.15e-05  $ _016_ (RSTB, shared by write-addr critical group) fine sweep point 14 (31.5us)
.measure tran fine_held_t14 FIND v(xdut.x2.rst_scl_domain_held) AT=3.15e-05  $ rst_scl_domain_held fine sweep point 14 (31.5us)
.measure tran fine_qn_t14 FIND v(xdut.x2.rst_stretch_qn) AT=3.15e-05  $ rst_stretch_qn fine sweep point 14 (31.5us)
.measure tran fine_raw_t14 FIND v(xdut.x2._143_) AT=3.15e-05  $ _143_ (rst_scl_domain_raw) fine sweep point 14 (31.5us)
.measure tran fine_clr_t14 FIND v(xdut.x2._144_) AT=3.15e-05  $ _144_ (rst_stretch_clr) fine sweep point 14 (31.5us)
.measure tran fine_d_t14 FIND v(xdut.x2._066_) AT=3.15e-05  $ _066_ (D input to bit_cnt_0's flop) fine sweep point 14 (31.5us)
.measure tran fine_qb_t14 FIND v(xdut.x2._212_) AT=3.15e-05  $ _212_ (QB output of bit_cnt_0's flop) fine sweep point 14 (31.5us)
.measure tran fine_qm_t14 FIND v(xdut.x2.x_505_.qm) AT=3.15e-05  $ internal QM (master latch out) of x_505_ fine sweep point 14 (31.5us)
.measure tran fine_net2_t14 FIND v(xdut.x2.x_505_.net2) AT=3.15e-05  $ internal net2 (master dynamic node) of x_505_ fine sweep point 14 (31.5us)
.measure tran fine_qs_t14 FIND v(xdut.x2.x_505_.qs) AT=3.15e-05  $ internal QS (slave latch out) of x_505_ fine sweep point 14 (31.5us)
.measure tran fine_net5_t14 FIND v(xdut.x2.x_505_.net5) AT=3.15e-05  $ internal net5 (slave dynamic node) of x_505_ fine sweep point 14 (31.5us)
.measure tran fine_bitcnt0_t15 FIND v(xdut.x2.bit_cnt_0) AT=3.25e-05  $ bit_cnt_0 fine sweep point 15 (32.5us)
.measure tran fine_ck_t15 FIND v(xdut.x2._156__row1) AT=3.25e-05  $ _156__row1 (shared clock net) fine sweep point 15 (32.5us)
.measure tran fine_rstb_t15 FIND v(xdut.x2._016_) AT=3.25e-05  $ _016_ (RSTB, shared by write-addr critical group) fine sweep point 15 (32.5us)
.measure tran fine_held_t15 FIND v(xdut.x2.rst_scl_domain_held) AT=3.25e-05  $ rst_scl_domain_held fine sweep point 15 (32.5us)
.measure tran fine_qn_t15 FIND v(xdut.x2.rst_stretch_qn) AT=3.25e-05  $ rst_stretch_qn fine sweep point 15 (32.5us)
.measure tran fine_raw_t15 FIND v(xdut.x2._143_) AT=3.25e-05  $ _143_ (rst_scl_domain_raw) fine sweep point 15 (32.5us)
.measure tran fine_clr_t15 FIND v(xdut.x2._144_) AT=3.25e-05  $ _144_ (rst_stretch_clr) fine sweep point 15 (32.5us)
.measure tran fine_d_t15 FIND v(xdut.x2._066_) AT=3.25e-05  $ _066_ (D input to bit_cnt_0's flop) fine sweep point 15 (32.5us)
.measure tran fine_qb_t15 FIND v(xdut.x2._212_) AT=3.25e-05  $ _212_ (QB output of bit_cnt_0's flop) fine sweep point 15 (32.5us)
.measure tran fine_qm_t15 FIND v(xdut.x2.x_505_.qm) AT=3.25e-05  $ internal QM (master latch out) of x_505_ fine sweep point 15 (32.5us)
.measure tran fine_net2_t15 FIND v(xdut.x2.x_505_.net2) AT=3.25e-05  $ internal net2 (master dynamic node) of x_505_ fine sweep point 15 (32.5us)
.measure tran fine_qs_t15 FIND v(xdut.x2.x_505_.qs) AT=3.25e-05  $ internal QS (slave latch out) of x_505_ fine sweep point 15 (32.5us)
.measure tran fine_net5_t15 FIND v(xdut.x2.x_505_.net5) AT=3.25e-05  $ internal net5 (slave dynamic node) of x_505_ fine sweep point 15 (32.5us)
.measure tran fine_bitcnt0_t16 FIND v(xdut.x2.bit_cnt_0) AT=3.35e-05  $ bit_cnt_0 fine sweep point 16 (33.5us)
.measure tran fine_ck_t16 FIND v(xdut.x2._156__row1) AT=3.35e-05  $ _156__row1 (shared clock net) fine sweep point 16 (33.5us)
.measure tran fine_rstb_t16 FIND v(xdut.x2._016_) AT=3.35e-05  $ _016_ (RSTB, shared by write-addr critical group) fine sweep point 16 (33.5us)
.measure tran fine_held_t16 FIND v(xdut.x2.rst_scl_domain_held) AT=3.35e-05  $ rst_scl_domain_held fine sweep point 16 (33.5us)
.measure tran fine_qn_t16 FIND v(xdut.x2.rst_stretch_qn) AT=3.35e-05  $ rst_stretch_qn fine sweep point 16 (33.5us)
.measure tran fine_raw_t16 FIND v(xdut.x2._143_) AT=3.35e-05  $ _143_ (rst_scl_domain_raw) fine sweep point 16 (33.5us)
.measure tran fine_clr_t16 FIND v(xdut.x2._144_) AT=3.35e-05  $ _144_ (rst_stretch_clr) fine sweep point 16 (33.5us)
.measure tran fine_d_t16 FIND v(xdut.x2._066_) AT=3.35e-05  $ _066_ (D input to bit_cnt_0's flop) fine sweep point 16 (33.5us)
.measure tran fine_qb_t16 FIND v(xdut.x2._212_) AT=3.35e-05  $ _212_ (QB output of bit_cnt_0's flop) fine sweep point 16 (33.5us)
.measure tran fine_qm_t16 FIND v(xdut.x2.x_505_.qm) AT=3.35e-05  $ internal QM (master latch out) of x_505_ fine sweep point 16 (33.5us)
.measure tran fine_net2_t16 FIND v(xdut.x2.x_505_.net2) AT=3.35e-05  $ internal net2 (master dynamic node) of x_505_ fine sweep point 16 (33.5us)
.measure tran fine_qs_t16 FIND v(xdut.x2.x_505_.qs) AT=3.35e-05  $ internal QS (slave latch out) of x_505_ fine sweep point 16 (33.5us)
.measure tran fine_net5_t16 FIND v(xdut.x2.x_505_.net5) AT=3.35e-05  $ internal net5 (slave dynamic node) of x_505_ fine sweep point 16 (33.5us)
.measure tran fine_bitcnt0_t17 FIND v(xdut.x2.bit_cnt_0) AT=3.45e-05  $ bit_cnt_0 fine sweep point 17 (34.5us)
.measure tran fine_ck_t17 FIND v(xdut.x2._156__row1) AT=3.45e-05  $ _156__row1 (shared clock net) fine sweep point 17 (34.5us)
.measure tran fine_rstb_t17 FIND v(xdut.x2._016_) AT=3.45e-05  $ _016_ (RSTB, shared by write-addr critical group) fine sweep point 17 (34.5us)
.measure tran fine_held_t17 FIND v(xdut.x2.rst_scl_domain_held) AT=3.45e-05  $ rst_scl_domain_held fine sweep point 17 (34.5us)
.measure tran fine_qn_t17 FIND v(xdut.x2.rst_stretch_qn) AT=3.45e-05  $ rst_stretch_qn fine sweep point 17 (34.5us)
.measure tran fine_raw_t17 FIND v(xdut.x2._143_) AT=3.45e-05  $ _143_ (rst_scl_domain_raw) fine sweep point 17 (34.5us)
.measure tran fine_clr_t17 FIND v(xdut.x2._144_) AT=3.45e-05  $ _144_ (rst_stretch_clr) fine sweep point 17 (34.5us)
.measure tran fine_d_t17 FIND v(xdut.x2._066_) AT=3.45e-05  $ _066_ (D input to bit_cnt_0's flop) fine sweep point 17 (34.5us)
.measure tran fine_qb_t17 FIND v(xdut.x2._212_) AT=3.45e-05  $ _212_ (QB output of bit_cnt_0's flop) fine sweep point 17 (34.5us)
.measure tran fine_qm_t17 FIND v(xdut.x2.x_505_.qm) AT=3.45e-05  $ internal QM (master latch out) of x_505_ fine sweep point 17 (34.5us)
.measure tran fine_net2_t17 FIND v(xdut.x2.x_505_.net2) AT=3.45e-05  $ internal net2 (master dynamic node) of x_505_ fine sweep point 17 (34.5us)
.measure tran fine_qs_t17 FIND v(xdut.x2.x_505_.qs) AT=3.45e-05  $ internal QS (slave latch out) of x_505_ fine sweep point 17 (34.5us)
.measure tran fine_net5_t17 FIND v(xdut.x2.x_505_.net5) AT=3.45e-05  $ internal net5 (slave dynamic node) of x_505_ fine sweep point 17 (34.5us)
.measure tran fine_bitcnt0_t18 FIND v(xdut.x2.bit_cnt_0) AT=3.55e-05  $ bit_cnt_0 fine sweep point 18 (35.5us)
.measure tran fine_ck_t18 FIND v(xdut.x2._156__row1) AT=3.55e-05  $ _156__row1 (shared clock net) fine sweep point 18 (35.5us)
.measure tran fine_rstb_t18 FIND v(xdut.x2._016_) AT=3.55e-05  $ _016_ (RSTB, shared by write-addr critical group) fine sweep point 18 (35.5us)
.measure tran fine_held_t18 FIND v(xdut.x2.rst_scl_domain_held) AT=3.55e-05  $ rst_scl_domain_held fine sweep point 18 (35.5us)
.measure tran fine_qn_t18 FIND v(xdut.x2.rst_stretch_qn) AT=3.55e-05  $ rst_stretch_qn fine sweep point 18 (35.5us)
.measure tran fine_raw_t18 FIND v(xdut.x2._143_) AT=3.55e-05  $ _143_ (rst_scl_domain_raw) fine sweep point 18 (35.5us)
.measure tran fine_clr_t18 FIND v(xdut.x2._144_) AT=3.55e-05  $ _144_ (rst_stretch_clr) fine sweep point 18 (35.5us)
.measure tran fine_d_t18 FIND v(xdut.x2._066_) AT=3.55e-05  $ _066_ (D input to bit_cnt_0's flop) fine sweep point 18 (35.5us)
.measure tran fine_qb_t18 FIND v(xdut.x2._212_) AT=3.55e-05  $ _212_ (QB output of bit_cnt_0's flop) fine sweep point 18 (35.5us)
.measure tran fine_qm_t18 FIND v(xdut.x2.x_505_.qm) AT=3.55e-05  $ internal QM (master latch out) of x_505_ fine sweep point 18 (35.5us)
.measure tran fine_net2_t18 FIND v(xdut.x2.x_505_.net2) AT=3.55e-05  $ internal net2 (master dynamic node) of x_505_ fine sweep point 18 (35.5us)
.measure tran fine_qs_t18 FIND v(xdut.x2.x_505_.qs) AT=3.55e-05  $ internal QS (slave latch out) of x_505_ fine sweep point 18 (35.5us)
.measure tran fine_net5_t18 FIND v(xdut.x2.x_505_.net5) AT=3.55e-05  $ internal net5 (slave dynamic node) of x_505_ fine sweep point 18 (35.5us)
.measure tran fine_bitcnt0_t19 FIND v(xdut.x2.bit_cnt_0) AT=3.65e-05  $ bit_cnt_0 fine sweep point 19 (36.5us)
.measure tran fine_ck_t19 FIND v(xdut.x2._156__row1) AT=3.65e-05  $ _156__row1 (shared clock net) fine sweep point 19 (36.5us)
.measure tran fine_rstb_t19 FIND v(xdut.x2._016_) AT=3.65e-05  $ _016_ (RSTB, shared by write-addr critical group) fine sweep point 19 (36.5us)
.measure tran fine_held_t19 FIND v(xdut.x2.rst_scl_domain_held) AT=3.65e-05  $ rst_scl_domain_held fine sweep point 19 (36.5us)
.measure tran fine_qn_t19 FIND v(xdut.x2.rst_stretch_qn) AT=3.65e-05  $ rst_stretch_qn fine sweep point 19 (36.5us)
.measure tran fine_raw_t19 FIND v(xdut.x2._143_) AT=3.65e-05  $ _143_ (rst_scl_domain_raw) fine sweep point 19 (36.5us)
.measure tran fine_clr_t19 FIND v(xdut.x2._144_) AT=3.65e-05  $ _144_ (rst_stretch_clr) fine sweep point 19 (36.5us)
.measure tran fine_d_t19 FIND v(xdut.x2._066_) AT=3.65e-05  $ _066_ (D input to bit_cnt_0's flop) fine sweep point 19 (36.5us)
.measure tran fine_qb_t19 FIND v(xdut.x2._212_) AT=3.65e-05  $ _212_ (QB output of bit_cnt_0's flop) fine sweep point 19 (36.5us)
.measure tran fine_qm_t19 FIND v(xdut.x2.x_505_.qm) AT=3.65e-05  $ internal QM (master latch out) of x_505_ fine sweep point 19 (36.5us)
.measure tran fine_net2_t19 FIND v(xdut.x2.x_505_.net2) AT=3.65e-05  $ internal net2 (master dynamic node) of x_505_ fine sweep point 19 (36.5us)
.measure tran fine_qs_t19 FIND v(xdut.x2.x_505_.qs) AT=3.65e-05  $ internal QS (slave latch out) of x_505_ fine sweep point 19 (36.5us)
.measure tran fine_net5_t19 FIND v(xdut.x2.x_505_.net5) AT=3.65e-05  $ internal net5 (slave dynamic node) of x_505_ fine sweep point 19 (36.5us)
.measure tran fine_bitcnt0_t20 FIND v(xdut.x2.bit_cnt_0) AT=3.75e-05  $ bit_cnt_0 fine sweep point 20 (37.5us)
.measure tran fine_ck_t20 FIND v(xdut.x2._156__row1) AT=3.75e-05  $ _156__row1 (shared clock net) fine sweep point 20 (37.5us)
.measure tran fine_rstb_t20 FIND v(xdut.x2._016_) AT=3.75e-05  $ _016_ (RSTB, shared by write-addr critical group) fine sweep point 20 (37.5us)
.measure tran fine_held_t20 FIND v(xdut.x2.rst_scl_domain_held) AT=3.75e-05  $ rst_scl_domain_held fine sweep point 20 (37.5us)
.measure tran fine_qn_t20 FIND v(xdut.x2.rst_stretch_qn) AT=3.75e-05  $ rst_stretch_qn fine sweep point 20 (37.5us)
.measure tran fine_raw_t20 FIND v(xdut.x2._143_) AT=3.75e-05  $ _143_ (rst_scl_domain_raw) fine sweep point 20 (37.5us)
.measure tran fine_clr_t20 FIND v(xdut.x2._144_) AT=3.75e-05  $ _144_ (rst_stretch_clr) fine sweep point 20 (37.5us)
.measure tran fine_d_t20 FIND v(xdut.x2._066_) AT=3.75e-05  $ _066_ (D input to bit_cnt_0's flop) fine sweep point 20 (37.5us)
.measure tran fine_qb_t20 FIND v(xdut.x2._212_) AT=3.75e-05  $ _212_ (QB output of bit_cnt_0's flop) fine sweep point 20 (37.5us)
.measure tran fine_qm_t20 FIND v(xdut.x2.x_505_.qm) AT=3.75e-05  $ internal QM (master latch out) of x_505_ fine sweep point 20 (37.5us)
.measure tran fine_net2_t20 FIND v(xdut.x2.x_505_.net2) AT=3.75e-05  $ internal net2 (master dynamic node) of x_505_ fine sweep point 20 (37.5us)
.measure tran fine_qs_t20 FIND v(xdut.x2.x_505_.qs) AT=3.75e-05  $ internal QS (slave latch out) of x_505_ fine sweep point 20 (37.5us)
.measure tran fine_net5_t20 FIND v(xdut.x2.x_505_.net5) AT=3.75e-05  $ internal net5 (slave dynamic node) of x_505_ fine sweep point 20 (37.5us)
.measure tran bc0_x1 WHEN v(xdut.x2.bit_cnt_0)=2.5 CROSS=1  $ bit_cnt_0 crossing #1
.measure tran bc0_x2 WHEN v(xdut.x2.bit_cnt_0)=2.5 CROSS=2  $ bit_cnt_0 crossing #2
.measure tran bc0_x3 WHEN v(xdut.x2.bit_cnt_0)=2.5 CROSS=3  $ bit_cnt_0 crossing #3
.measure tran bc0_x4 WHEN v(xdut.x2.bit_cnt_0)=2.5 CROSS=4  $ bit_cnt_0 crossing #4
.measure tran bc0_x5 WHEN v(xdut.x2.bit_cnt_0)=2.5 CROSS=5  $ bit_cnt_0 crossing #5
.measure tran bc0_x6 WHEN v(xdut.x2.bit_cnt_0)=2.5 CROSS=6  $ bit_cnt_0 crossing #6
.measure tran bc0_x7 WHEN v(xdut.x2.bit_cnt_0)=2.5 CROSS=7  $ bit_cnt_0 crossing #7
.measure tran bc0_x8 WHEN v(xdut.x2.bit_cnt_0)=2.5 CROSS=8  $ bit_cnt_0 crossing #8
.measure tran bc1_x1 WHEN v(xdut.x2.bit_cnt_1)=2.5 CROSS=1  $ bit_cnt_1 crossing #1
.measure tran bc1_x2 WHEN v(xdut.x2.bit_cnt_1)=2.5 CROSS=2  $ bit_cnt_1 crossing #2
.measure tran bc1_x3 WHEN v(xdut.x2.bit_cnt_1)=2.5 CROSS=3  $ bit_cnt_1 crossing #3
.measure tran bc1_x4 WHEN v(xdut.x2.bit_cnt_1)=2.5 CROSS=4  $ bit_cnt_1 crossing #4
.measure tran bc1_x5 WHEN v(xdut.x2.bit_cnt_1)=2.5 CROSS=5  $ bit_cnt_1 crossing #5
.measure tran bc1_x6 WHEN v(xdut.x2.bit_cnt_1)=2.5 CROSS=6  $ bit_cnt_1 crossing #6
.measure tran bc2_x1 WHEN v(xdut.x2.bit_cnt_2)=2.5 CROSS=1  $ bit_cnt_2 crossing #1
.measure tran bc2_x2 WHEN v(xdut.x2.bit_cnt_2)=2.5 CROSS=2  $ bit_cnt_2 crossing #2
.measure tran bc2_x3 WHEN v(xdut.x2.bit_cnt_2)=2.5 CROSS=3  $ bit_cnt_2 crossing #3
.measure tran bc2_x4 WHEN v(xdut.x2.bit_cnt_2)=2.5 CROSS=4  $ bit_cnt_2 crossing #4
.measure tran d004_x1 WHEN v(xdut.x2._004_)=2.5 RISE=1  $ _004_ (D of last_bit_pending) first rise
.measure tran lbp_x1 WHEN v(xdut.x2.last_bit_pending)=2.5 RISE=1  $ last_bit_pending first rise
.measure tran ck_x1 WHEN v(xdut.x2._156__row1)=2.5 RISE=1  $ CK (_156__row1) first rise, timing reference
.measure tran d_066_e1 FIND v(xdut.x2._066_) AT=1.75e-05  $ _066_ at e1 (17.5us) -- bit_cnt_0 D-logic cone
.measure tran d_100_e1 FIND v(xdut.x2._100_) AT=1.75e-05  $ _100_ at e1 (17.5us) -- bit_cnt_0 D-logic cone
.measure tran d_111_e1 FIND v(xdut.x2._111_) AT=1.75e-05  $ _111_ at e1 (17.5us) -- bit_cnt_0 D-logic cone
.measure tran d_094_e1 FIND v(xdut.x2._094_) AT=1.75e-05  $ _094_ at e1 (17.5us) -- bit_cnt_0 D-logic cone
.measure tran d_085_e1 FIND v(xdut.x2._085_) AT=1.75e-05  $ _085_ at e1 (17.5us) -- bit_cnt_0 D-logic cone
.measure tran d_098_e1 FIND v(xdut.x2._098_) AT=1.75e-05  $ _098_ at e1 (17.5us) -- bit_cnt_0 D-logic cone
.measure tran d_099_e1 FIND v(xdut.x2._099_) AT=1.75e-05  $ _099_ at e1 (17.5us) -- bit_cnt_0 D-logic cone
.measure tran d_110_e1 FIND v(xdut.x2._110_) AT=1.75e-05  $ _110_ at e1 (17.5us) -- bit_cnt_0 D-logic cone
.measure tran bc0_e1 FIND v(xdut.x2.bit_cnt_0) AT=1.75e-05  $ bit_cnt_0 at e1 (17.5us) -- bit_cnt_0 D-logic cone
.measure tran bc0_qb_e1 FIND v(xdut.x2._212_) AT=1.75e-05  $ _212_ at e1 (17.5us) -- bit_cnt_0 D-logic cone
.measure tran d_066_mid FIND v(xdut.x2._066_) AT=2.2e-05  $ _066_ at mid (22.0us) -- bit_cnt_0 D-logic cone
.measure tran d_100_mid FIND v(xdut.x2._100_) AT=2.2e-05  $ _100_ at mid (22.0us) -- bit_cnt_0 D-logic cone
.measure tran d_111_mid FIND v(xdut.x2._111_) AT=2.2e-05  $ _111_ at mid (22.0us) -- bit_cnt_0 D-logic cone
.measure tran d_094_mid FIND v(xdut.x2._094_) AT=2.2e-05  $ _094_ at mid (22.0us) -- bit_cnt_0 D-logic cone
.measure tran d_085_mid FIND v(xdut.x2._085_) AT=2.2e-05  $ _085_ at mid (22.0us) -- bit_cnt_0 D-logic cone
.measure tran d_098_mid FIND v(xdut.x2._098_) AT=2.2e-05  $ _098_ at mid (22.0us) -- bit_cnt_0 D-logic cone
.measure tran d_099_mid FIND v(xdut.x2._099_) AT=2.2e-05  $ _099_ at mid (22.0us) -- bit_cnt_0 D-logic cone
.measure tran d_110_mid FIND v(xdut.x2._110_) AT=2.2e-05  $ _110_ at mid (22.0us) -- bit_cnt_0 D-logic cone
.measure tran bc0_mid FIND v(xdut.x2.bit_cnt_0) AT=2.2e-05  $ bit_cnt_0 at mid (22.0us) -- bit_cnt_0 D-logic cone
.measure tran bc0_qb_mid FIND v(xdut.x2._212_) AT=2.2e-05  $ _212_ at mid (22.0us) -- bit_cnt_0 D-logic cone
.measure tran d_066_e2pre FIND v(xdut.x2._066_) AT=2.69e-05  $ _066_ at e2pre (26.9us) -- bit_cnt_0 D-logic cone
.measure tran d_100_e2pre FIND v(xdut.x2._100_) AT=2.69e-05  $ _100_ at e2pre (26.9us) -- bit_cnt_0 D-logic cone
.measure tran d_111_e2pre FIND v(xdut.x2._111_) AT=2.69e-05  $ _111_ at e2pre (26.9us) -- bit_cnt_0 D-logic cone
.measure tran d_094_e2pre FIND v(xdut.x2._094_) AT=2.69e-05  $ _094_ at e2pre (26.9us) -- bit_cnt_0 D-logic cone
.measure tran d_085_e2pre FIND v(xdut.x2._085_) AT=2.69e-05  $ _085_ at e2pre (26.9us) -- bit_cnt_0 D-logic cone
.measure tran d_098_e2pre FIND v(xdut.x2._098_) AT=2.69e-05  $ _098_ at e2pre (26.9us) -- bit_cnt_0 D-logic cone
.measure tran d_099_e2pre FIND v(xdut.x2._099_) AT=2.69e-05  $ _099_ at e2pre (26.9us) -- bit_cnt_0 D-logic cone
.measure tran d_110_e2pre FIND v(xdut.x2._110_) AT=2.69e-05  $ _110_ at e2pre (26.9us) -- bit_cnt_0 D-logic cone
.measure tran bc0_e2pre FIND v(xdut.x2.bit_cnt_0) AT=2.69e-05  $ bit_cnt_0 at e2pre (26.9us) -- bit_cnt_0 D-logic cone
.measure tran bc0_qb_e2pre FIND v(xdut.x2._212_) AT=2.69e-05  $ _212_ at e2pre (26.9us) -- bit_cnt_0 D-logic cone
.measure tran tl_scl_row2_x1 WHEN v(xdut.x2.scl_row2)=2.5 CROSS=1  $ scl_row2 crossing #1 (timeline reconstruction)
.measure tran tl_scl_row2_x2 WHEN v(xdut.x2.scl_row2)=2.5 CROSS=2  $ scl_row2 crossing #2 (timeline reconstruction)
.measure tran tl_scl_row2_x3 WHEN v(xdut.x2.scl_row2)=2.5 CROSS=3  $ scl_row2 crossing #3 (timeline reconstruction)
.measure tran tl_scl_row2_x4 WHEN v(xdut.x2.scl_row2)=2.5 CROSS=4  $ scl_row2 crossing #4 (timeline reconstruction)
.measure tran tl_016_x1 WHEN v(xdut.x2._016_)=2.5 CROSS=1  $ _016_ crossing #1 (timeline reconstruction)
.measure tran tl_016_x2 WHEN v(xdut.x2._016_)=2.5 CROSS=2  $ _016_ crossing #2 (timeline reconstruction)
.measure tran tl_016_x3 WHEN v(xdut.x2._016_)=2.5 CROSS=3  $ _016_ crossing #3 (timeline reconstruction)
.measure tran tl_016_x4 WHEN v(xdut.x2._016_)=2.5 CROSS=4  $ _016_ crossing #4 (timeline reconstruction)
.measure tran tl_rst_scl_domain_held_x1 WHEN v(xdut.x2.rst_scl_domain_held)=2.5 CROSS=1  $ rst_scl_domain_held crossing #1 (timeline reconstruction)
.measure tran tl_rst_scl_domain_held_x2 WHEN v(xdut.x2.rst_scl_domain_held)=2.5 CROSS=2  $ rst_scl_domain_held crossing #2 (timeline reconstruction)
.measure tran tl_rst_scl_domain_held_x3 WHEN v(xdut.x2.rst_scl_domain_held)=2.5 CROSS=3  $ rst_scl_domain_held crossing #3 (timeline reconstruction)
.measure tran tl_rst_scl_domain_held_x4 WHEN v(xdut.x2.rst_scl_domain_held)=2.5 CROSS=4  $ rst_scl_domain_held crossing #4 (timeline reconstruction)
.measure tran tl_rst_stretch_qn_x1 WHEN v(xdut.x2.rst_stretch_qn)=2.5 CROSS=1  $ rst_stretch_qn crossing #1 (timeline reconstruction)
.measure tran tl_rst_stretch_qn_x2 WHEN v(xdut.x2.rst_stretch_qn)=2.5 CROSS=2  $ rst_stretch_qn crossing #2 (timeline reconstruction)
.measure tran tl_rst_stretch_qn_x3 WHEN v(xdut.x2.rst_stretch_qn)=2.5 CROSS=3  $ rst_stretch_qn crossing #3 (timeline reconstruction)
.measure tran tl_rst_stretch_qn_x4 WHEN v(xdut.x2.rst_stretch_qn)=2.5 CROSS=4  $ rst_stretch_qn crossing #4 (timeline reconstruction)
.measure tran tl_143_x1 WHEN v(xdut.x2._143_)=2.5 CROSS=1  $ _143_ crossing #1 (timeline reconstruction)
.measure tran tl_143_x2 WHEN v(xdut.x2._143_)=2.5 CROSS=2  $ _143_ crossing #2 (timeline reconstruction)
.measure tran tl_143_x3 WHEN v(xdut.x2._143_)=2.5 CROSS=3  $ _143_ crossing #3 (timeline reconstruction)
.measure tran tl_143_x4 WHEN v(xdut.x2._143_)=2.5 CROSS=4  $ _143_ crossing #4 (timeline reconstruction)
.measure tran tl_144_x1 WHEN v(xdut.x2._144_)=2.5 CROSS=1  $ _144_ crossing #1 (timeline reconstruction)
.measure tran tl_144_x2 WHEN v(xdut.x2._144_)=2.5 CROSS=2  $ _144_ crossing #2 (timeline reconstruction)
.measure tran tl_144_x3 WHEN v(xdut.x2._144_)=2.5 CROSS=3  $ _144_ crossing #3 (timeline reconstruction)
.measure tran tl_144_x4 WHEN v(xdut.x2._144_)=2.5 CROSS=4  $ _144_ crossing #4 (timeline reconstruction)
.measure tran tl_156_x1 WHEN v(xdut.x2._156_)=2.5 CROSS=1  $ _156_ crossing #1 (timeline reconstruction)
.measure tran tl_156_x2 WHEN v(xdut.x2._156_)=2.5 CROSS=2  $ _156_ crossing #2 (timeline reconstruction)
.measure tran tl_156_x3 WHEN v(xdut.x2._156_)=2.5 CROSS=3  $ _156_ crossing #3 (timeline reconstruction)
.measure tran tl_156_x4 WHEN v(xdut.x2._156_)=2.5 CROSS=4  $ _156_ crossing #4 (timeline reconstruction)
.measure tran tl_156__row1_x1 WHEN v(xdut.x2._156__row1)=2.5 CROSS=1  $ _156__row1 crossing #1 (timeline reconstruction)
.measure tran tl_156__row1_x2 WHEN v(xdut.x2._156__row1)=2.5 CROSS=2  $ _156__row1 crossing #2 (timeline reconstruction)
.measure tran tl_156__row1_x3 WHEN v(xdut.x2._156__row1)=2.5 CROSS=3  $ _156__row1 crossing #3 (timeline reconstruction)
.measure tran tl_156__row1_x4 WHEN v(xdut.x2._156__row1)=2.5 CROSS=4  $ _156__row1 crossing #4 (timeline reconstruction)
.measure tran g2_143_x1 WHEN v(xdut.x2._143_)=2.5 CROSS=1  $ _143_ crossing #1 (round 8: RSTB glitch trace)
.measure tran g2_143_x2 WHEN v(xdut.x2._143_)=2.5 CROSS=2  $ _143_ crossing #2 (round 8: RSTB glitch trace)
.measure tran g2_143_x3 WHEN v(xdut.x2._143_)=2.5 CROSS=3  $ _143_ crossing #3 (round 8: RSTB glitch trace)
.measure tran g2_143_x4 WHEN v(xdut.x2._143_)=2.5 CROSS=4  $ _143_ crossing #4 (round 8: RSTB glitch trace)
.measure tran g2_143_x5 WHEN v(xdut.x2._143_)=2.5 CROSS=5  $ _143_ crossing #5 (round 8: RSTB glitch trace)
.measure tran g2_143_x6 WHEN v(xdut.x2._143_)=2.5 CROSS=6  $ _143_ crossing #6 (round 8: RSTB glitch trace)
.measure tran g2_143_x7 WHEN v(xdut.x2._143_)=2.5 CROSS=7  $ _143_ crossing #7 (round 8: RSTB glitch trace)
.measure tran g2_143_x8 WHEN v(xdut.x2._143_)=2.5 CROSS=8  $ _143_ crossing #8 (round 8: RSTB glitch trace)
.measure tran g2_143_x9 WHEN v(xdut.x2._143_)=2.5 CROSS=9  $ _143_ crossing #9 (round 8: RSTB glitch trace)
.measure tran g2_143_x10 WHEN v(xdut.x2._143_)=2.5 CROSS=10  $ _143_ crossing #10 (round 8: RSTB glitch trace)
.measure tran g2_143_x11 WHEN v(xdut.x2._143_)=2.5 CROSS=11  $ _143_ crossing #11 (round 8: RSTB glitch trace)
.measure tran g2_143_x12 WHEN v(xdut.x2._143_)=2.5 CROSS=12  $ _143_ crossing #12 (round 8: RSTB glitch trace)
.measure tran g2_143_x13 WHEN v(xdut.x2._143_)=2.5 CROSS=13  $ _143_ crossing #13 (round 8: RSTB glitch trace)
.measure tran g2_143_x14 WHEN v(xdut.x2._143_)=2.5 CROSS=14  $ _143_ crossing #14 (round 8: RSTB glitch trace)
.measure tran g2_143_x15 WHEN v(xdut.x2._143_)=2.5 CROSS=15  $ _143_ crossing #15 (round 8: RSTB glitch trace)
.measure tran g2_143_x16 WHEN v(xdut.x2._143_)=2.5 CROSS=16  $ _143_ crossing #16 (round 8: RSTB glitch trace)
.measure tran g2_144_x1 WHEN v(xdut.x2._144_)=2.5 CROSS=1  $ _144_ crossing #1 (round 8: RSTB glitch trace)
.measure tran g2_144_x2 WHEN v(xdut.x2._144_)=2.5 CROSS=2  $ _144_ crossing #2 (round 8: RSTB glitch trace)
.measure tran g2_144_x3 WHEN v(xdut.x2._144_)=2.5 CROSS=3  $ _144_ crossing #3 (round 8: RSTB glitch trace)
.measure tran g2_144_x4 WHEN v(xdut.x2._144_)=2.5 CROSS=4  $ _144_ crossing #4 (round 8: RSTB glitch trace)
.measure tran g2_144_x5 WHEN v(xdut.x2._144_)=2.5 CROSS=5  $ _144_ crossing #5 (round 8: RSTB glitch trace)
.measure tran g2_144_x6 WHEN v(xdut.x2._144_)=2.5 CROSS=6  $ _144_ crossing #6 (round 8: RSTB glitch trace)
.measure tran g2_144_x7 WHEN v(xdut.x2._144_)=2.5 CROSS=7  $ _144_ crossing #7 (round 8: RSTB glitch trace)
.measure tran g2_144_x8 WHEN v(xdut.x2._144_)=2.5 CROSS=8  $ _144_ crossing #8 (round 8: RSTB glitch trace)
.measure tran g2_144_x9 WHEN v(xdut.x2._144_)=2.5 CROSS=9  $ _144_ crossing #9 (round 8: RSTB glitch trace)
.measure tran g2_144_x10 WHEN v(xdut.x2._144_)=2.5 CROSS=10  $ _144_ crossing #10 (round 8: RSTB glitch trace)
.measure tran g2_144_x11 WHEN v(xdut.x2._144_)=2.5 CROSS=11  $ _144_ crossing #11 (round 8: RSTB glitch trace)
.measure tran g2_144_x12 WHEN v(xdut.x2._144_)=2.5 CROSS=12  $ _144_ crossing #12 (round 8: RSTB glitch trace)
.measure tran g2_144_x13 WHEN v(xdut.x2._144_)=2.5 CROSS=13  $ _144_ crossing #13 (round 8: RSTB glitch trace)
.measure tran g2_144_x14 WHEN v(xdut.x2._144_)=2.5 CROSS=14  $ _144_ crossing #14 (round 8: RSTB glitch trace)
.measure tran g2_144_x15 WHEN v(xdut.x2._144_)=2.5 CROSS=15  $ _144_ crossing #15 (round 8: RSTB glitch trace)
.measure tran g2_144_x16 WHEN v(xdut.x2._144_)=2.5 CROSS=16  $ _144_ crossing #16 (round 8: RSTB glitch trace)
.measure tran g2_rst_scl_domain_held_x1 WHEN v(xdut.x2.rst_scl_domain_held)=2.5 CROSS=1  $ rst_scl_domain_held crossing #1 (round 8: RSTB glitch trace)
.measure tran g2_rst_scl_domain_held_x2 WHEN v(xdut.x2.rst_scl_domain_held)=2.5 CROSS=2  $ rst_scl_domain_held crossing #2 (round 8: RSTB glitch trace)
.measure tran g2_rst_scl_domain_held_x3 WHEN v(xdut.x2.rst_scl_domain_held)=2.5 CROSS=3  $ rst_scl_domain_held crossing #3 (round 8: RSTB glitch trace)
.measure tran g2_rst_scl_domain_held_x4 WHEN v(xdut.x2.rst_scl_domain_held)=2.5 CROSS=4  $ rst_scl_domain_held crossing #4 (round 8: RSTB glitch trace)
.measure tran g2_rst_scl_domain_held_x5 WHEN v(xdut.x2.rst_scl_domain_held)=2.5 CROSS=5  $ rst_scl_domain_held crossing #5 (round 8: RSTB glitch trace)
.measure tran g2_rst_scl_domain_held_x6 WHEN v(xdut.x2.rst_scl_domain_held)=2.5 CROSS=6  $ rst_scl_domain_held crossing #6 (round 8: RSTB glitch trace)
.measure tran g2_rst_scl_domain_held_x7 WHEN v(xdut.x2.rst_scl_domain_held)=2.5 CROSS=7  $ rst_scl_domain_held crossing #7 (round 8: RSTB glitch trace)
.measure tran g2_rst_scl_domain_held_x8 WHEN v(xdut.x2.rst_scl_domain_held)=2.5 CROSS=8  $ rst_scl_domain_held crossing #8 (round 8: RSTB glitch trace)
.measure tran g2_rst_scl_domain_held_x9 WHEN v(xdut.x2.rst_scl_domain_held)=2.5 CROSS=9  $ rst_scl_domain_held crossing #9 (round 8: RSTB glitch trace)
.measure tran g2_rst_scl_domain_held_x10 WHEN v(xdut.x2.rst_scl_domain_held)=2.5 CROSS=10  $ rst_scl_domain_held crossing #10 (round 8: RSTB glitch trace)
.measure tran g2_rst_scl_domain_held_x11 WHEN v(xdut.x2.rst_scl_domain_held)=2.5 CROSS=11  $ rst_scl_domain_held crossing #11 (round 8: RSTB glitch trace)
.measure tran g2_rst_scl_domain_held_x12 WHEN v(xdut.x2.rst_scl_domain_held)=2.5 CROSS=12  $ rst_scl_domain_held crossing #12 (round 8: RSTB glitch trace)
.measure tran g2_rst_scl_domain_held_x13 WHEN v(xdut.x2.rst_scl_domain_held)=2.5 CROSS=13  $ rst_scl_domain_held crossing #13 (round 8: RSTB glitch trace)
.measure tran g2_rst_scl_domain_held_x14 WHEN v(xdut.x2.rst_scl_domain_held)=2.5 CROSS=14  $ rst_scl_domain_held crossing #14 (round 8: RSTB glitch trace)
.measure tran g2_rst_scl_domain_held_x15 WHEN v(xdut.x2.rst_scl_domain_held)=2.5 CROSS=15  $ rst_scl_domain_held crossing #15 (round 8: RSTB glitch trace)
.measure tran g2_rst_scl_domain_held_x16 WHEN v(xdut.x2.rst_scl_domain_held)=2.5 CROSS=16  $ rst_scl_domain_held crossing #16 (round 8: RSTB glitch trace)
.measure tran g2_rst_stretch_qn_x1 WHEN v(xdut.x2.rst_stretch_qn)=2.5 CROSS=1  $ rst_stretch_qn crossing #1 (round 8: RSTB glitch trace)
.measure tran g2_rst_stretch_qn_x2 WHEN v(xdut.x2.rst_stretch_qn)=2.5 CROSS=2  $ rst_stretch_qn crossing #2 (round 8: RSTB glitch trace)
.measure tran g2_rst_stretch_qn_x3 WHEN v(xdut.x2.rst_stretch_qn)=2.5 CROSS=3  $ rst_stretch_qn crossing #3 (round 8: RSTB glitch trace)
.measure tran g2_rst_stretch_qn_x4 WHEN v(xdut.x2.rst_stretch_qn)=2.5 CROSS=4  $ rst_stretch_qn crossing #4 (round 8: RSTB glitch trace)
.measure tran g2_rst_stretch_qn_x5 WHEN v(xdut.x2.rst_stretch_qn)=2.5 CROSS=5  $ rst_stretch_qn crossing #5 (round 8: RSTB glitch trace)
.measure tran g2_rst_stretch_qn_x6 WHEN v(xdut.x2.rst_stretch_qn)=2.5 CROSS=6  $ rst_stretch_qn crossing #6 (round 8: RSTB glitch trace)
.measure tran g2_rst_stretch_qn_x7 WHEN v(xdut.x2.rst_stretch_qn)=2.5 CROSS=7  $ rst_stretch_qn crossing #7 (round 8: RSTB glitch trace)
.measure tran g2_rst_stretch_qn_x8 WHEN v(xdut.x2.rst_stretch_qn)=2.5 CROSS=8  $ rst_stretch_qn crossing #8 (round 8: RSTB glitch trace)
.measure tran g2_rst_stretch_qn_x9 WHEN v(xdut.x2.rst_stretch_qn)=2.5 CROSS=9  $ rst_stretch_qn crossing #9 (round 8: RSTB glitch trace)
.measure tran g2_rst_stretch_qn_x10 WHEN v(xdut.x2.rst_stretch_qn)=2.5 CROSS=10  $ rst_stretch_qn crossing #10 (round 8: RSTB glitch trace)
.measure tran g2_rst_stretch_qn_x11 WHEN v(xdut.x2.rst_stretch_qn)=2.5 CROSS=11  $ rst_stretch_qn crossing #11 (round 8: RSTB glitch trace)
.measure tran g2_rst_stretch_qn_x12 WHEN v(xdut.x2.rst_stretch_qn)=2.5 CROSS=12  $ rst_stretch_qn crossing #12 (round 8: RSTB glitch trace)
.measure tran g2_rst_stretch_qn_x13 WHEN v(xdut.x2.rst_stretch_qn)=2.5 CROSS=13  $ rst_stretch_qn crossing #13 (round 8: RSTB glitch trace)
.measure tran g2_rst_stretch_qn_x14 WHEN v(xdut.x2.rst_stretch_qn)=2.5 CROSS=14  $ rst_stretch_qn crossing #14 (round 8: RSTB glitch trace)
.measure tran g2_rst_stretch_qn_x15 WHEN v(xdut.x2.rst_stretch_qn)=2.5 CROSS=15  $ rst_stretch_qn crossing #15 (round 8: RSTB glitch trace)
.measure tran g2_rst_stretch_qn_x16 WHEN v(xdut.x2.rst_stretch_qn)=2.5 CROSS=16  $ rst_stretch_qn crossing #16 (round 8: RSTB glitch trace)
.measure tran g2_016_x1 WHEN v(xdut.x2._016_)=2.5 CROSS=1  $ _016_ crossing #1 (round 8: RSTB glitch trace)
.measure tran g2_016_x2 WHEN v(xdut.x2._016_)=2.5 CROSS=2  $ _016_ crossing #2 (round 8: RSTB glitch trace)
.measure tran g2_016_x3 WHEN v(xdut.x2._016_)=2.5 CROSS=3  $ _016_ crossing #3 (round 8: RSTB glitch trace)
.measure tran g2_016_x4 WHEN v(xdut.x2._016_)=2.5 CROSS=4  $ _016_ crossing #4 (round 8: RSTB glitch trace)
.measure tran g2_016_x5 WHEN v(xdut.x2._016_)=2.5 CROSS=5  $ _016_ crossing #5 (round 8: RSTB glitch trace)
.measure tran g2_016_x6 WHEN v(xdut.x2._016_)=2.5 CROSS=6  $ _016_ crossing #6 (round 8: RSTB glitch trace)
.measure tran g2_016_x7 WHEN v(xdut.x2._016_)=2.5 CROSS=7  $ _016_ crossing #7 (round 8: RSTB glitch trace)
.measure tran g2_016_x8 WHEN v(xdut.x2._016_)=2.5 CROSS=8  $ _016_ crossing #8 (round 8: RSTB glitch trace)
.measure tran g2_016_x9 WHEN v(xdut.x2._016_)=2.5 CROSS=9  $ _016_ crossing #9 (round 8: RSTB glitch trace)
.measure tran g2_016_x10 WHEN v(xdut.x2._016_)=2.5 CROSS=10  $ _016_ crossing #10 (round 8: RSTB glitch trace)
.measure tran g2_016_x11 WHEN v(xdut.x2._016_)=2.5 CROSS=11  $ _016_ crossing #11 (round 8: RSTB glitch trace)
.measure tran g2_016_x12 WHEN v(xdut.x2._016_)=2.5 CROSS=12  $ _016_ crossing #12 (round 8: RSTB glitch trace)
.measure tran g2_016_x13 WHEN v(xdut.x2._016_)=2.5 CROSS=13  $ _016_ crossing #13 (round 8: RSTB glitch trace)
.measure tran g2_016_x14 WHEN v(xdut.x2._016_)=2.5 CROSS=14  $ _016_ crossing #14 (round 8: RSTB glitch trace)
.measure tran g2_016_x15 WHEN v(xdut.x2._016_)=2.5 CROSS=15  $ _016_ crossing #15 (round 8: RSTB glitch trace)
.measure tran g2_016_x16 WHEN v(xdut.x2._016_)=2.5 CROSS=16  $ _016_ crossing #16 (round 8: RSTB glitch trace)

* ---- diagnostic: exact internal comparator-chain nodes (hand-traced
* from the actual gate-level netlist) ----
.measure tran last_bit_pending_write FIND v(xdut.x2.last_bit_pending) AT=8.9e-05  $ comparator-chain node, right after the ADDR+W last-bit SCL edge
.measure tran phase_0_write FIND v(xdut.x2.phase_0) AT=8.9e-05  $ comparator-chain node, right after the ADDR+W last-bit SCL edge
.measure tran phase_1_write FIND v(xdut.x2.phase_1) AT=8.9e-05  $ comparator-chain node, right after the ADDR+W last-bit SCL edge
.measure tran phase_2_write FIND v(xdut.x2.phase_2) AT=8.9e-05  $ comparator-chain node, right after the ADDR+W last-bit SCL edge
.measure tran last_bit_pending_read FIND v(xdut.x2.last_bit_pending) AT=0.000299  $ comparator-chain node, right after the ADDR+R last-bit SCL edge
.measure tran phase_0_read FIND v(xdut.x2.phase_0) AT=0.000299  $ comparator-chain node, right after the ADDR+R last-bit SCL edge
.measure tran phase_1_read FIND v(xdut.x2.phase_1) AT=0.000299  $ comparator-chain node, right after the ADDR+R last-bit SCL edge
.measure tran phase_2_read FIND v(xdut.x2.phase_2) AT=0.000299  $ comparator-chain node, right after the ADDR+R last-bit SCL edge

* ---- diagnostic: bit_cnt_0/1/2 + last_bit_pending numeric trajectory at
* every ADDR+W bit edge (edge1..edge8) ----
.measure tran bit_cnt_0_edge1 FIND v(xdut.x2.bit_cnt_0) AT=1.9e-05  $ bit_cnt_0 2us after ADDR+W bit7's SCL rising edge (edge 1 of 8)
.measure tran bit_cnt_1_edge1 FIND v(xdut.x2.bit_cnt_1) AT=1.9e-05  $ bit_cnt_1 2us after ADDR+W bit7's SCL rising edge (edge 1 of 8)
.measure tran bit_cnt_2_edge1 FIND v(xdut.x2.bit_cnt_2) AT=1.9e-05  $ bit_cnt_2 2us after ADDR+W bit7's SCL rising edge (edge 1 of 8)
.measure tran lbp_edge1 FIND v(xdut.x2.last_bit_pending) AT=1.9e-05  $ last_bit_pending 2us after ADDR+W bit7's SCL rising edge (edge 1 of 8)
.measure tran bit_cnt_0_edge2 FIND v(xdut.x2.bit_cnt_0) AT=2.9e-05  $ bit_cnt_0 2us after ADDR+W bit6's SCL rising edge (edge 2 of 8)
.measure tran bit_cnt_1_edge2 FIND v(xdut.x2.bit_cnt_1) AT=2.9e-05  $ bit_cnt_1 2us after ADDR+W bit6's SCL rising edge (edge 2 of 8)
.measure tran bit_cnt_2_edge2 FIND v(xdut.x2.bit_cnt_2) AT=2.9e-05  $ bit_cnt_2 2us after ADDR+W bit6's SCL rising edge (edge 2 of 8)
.measure tran lbp_edge2 FIND v(xdut.x2.last_bit_pending) AT=2.9e-05  $ last_bit_pending 2us after ADDR+W bit6's SCL rising edge (edge 2 of 8)
.measure tran bit_cnt_0_edge3 FIND v(xdut.x2.bit_cnt_0) AT=3.9e-05  $ bit_cnt_0 2us after ADDR+W bit5's SCL rising edge (edge 3 of 8)
.measure tran bit_cnt_1_edge3 FIND v(xdut.x2.bit_cnt_1) AT=3.9e-05  $ bit_cnt_1 2us after ADDR+W bit5's SCL rising edge (edge 3 of 8)
.measure tran bit_cnt_2_edge3 FIND v(xdut.x2.bit_cnt_2) AT=3.9e-05  $ bit_cnt_2 2us after ADDR+W bit5's SCL rising edge (edge 3 of 8)
.measure tran lbp_edge3 FIND v(xdut.x2.last_bit_pending) AT=3.9e-05  $ last_bit_pending 2us after ADDR+W bit5's SCL rising edge (edge 3 of 8)
.measure tran bit_cnt_0_edge4 FIND v(xdut.x2.bit_cnt_0) AT=4.9e-05  $ bit_cnt_0 2us after ADDR+W bit4's SCL rising edge (edge 4 of 8)
.measure tran bit_cnt_1_edge4 FIND v(xdut.x2.bit_cnt_1) AT=4.9e-05  $ bit_cnt_1 2us after ADDR+W bit4's SCL rising edge (edge 4 of 8)
.measure tran bit_cnt_2_edge4 FIND v(xdut.x2.bit_cnt_2) AT=4.9e-05  $ bit_cnt_2 2us after ADDR+W bit4's SCL rising edge (edge 4 of 8)
.measure tran lbp_edge4 FIND v(xdut.x2.last_bit_pending) AT=4.9e-05  $ last_bit_pending 2us after ADDR+W bit4's SCL rising edge (edge 4 of 8)
.measure tran bit_cnt_0_edge5 FIND v(xdut.x2.bit_cnt_0) AT=5.9e-05  $ bit_cnt_0 2us after ADDR+W bit3's SCL rising edge (edge 5 of 8)
.measure tran bit_cnt_1_edge5 FIND v(xdut.x2.bit_cnt_1) AT=5.9e-05  $ bit_cnt_1 2us after ADDR+W bit3's SCL rising edge (edge 5 of 8)
.measure tran bit_cnt_2_edge5 FIND v(xdut.x2.bit_cnt_2) AT=5.9e-05  $ bit_cnt_2 2us after ADDR+W bit3's SCL rising edge (edge 5 of 8)
.measure tran lbp_edge5 FIND v(xdut.x2.last_bit_pending) AT=5.9e-05  $ last_bit_pending 2us after ADDR+W bit3's SCL rising edge (edge 5 of 8)
.measure tran bit_cnt_0_edge6 FIND v(xdut.x2.bit_cnt_0) AT=6.9e-05  $ bit_cnt_0 2us after ADDR+W bit2's SCL rising edge (edge 6 of 8)
.measure tran bit_cnt_1_edge6 FIND v(xdut.x2.bit_cnt_1) AT=6.9e-05  $ bit_cnt_1 2us after ADDR+W bit2's SCL rising edge (edge 6 of 8)
.measure tran bit_cnt_2_edge6 FIND v(xdut.x2.bit_cnt_2) AT=6.9e-05  $ bit_cnt_2 2us after ADDR+W bit2's SCL rising edge (edge 6 of 8)
.measure tran lbp_edge6 FIND v(xdut.x2.last_bit_pending) AT=6.9e-05  $ last_bit_pending 2us after ADDR+W bit2's SCL rising edge (edge 6 of 8)
.measure tran bit_cnt_0_edge7 FIND v(xdut.x2.bit_cnt_0) AT=7.9e-05  $ bit_cnt_0 2us after ADDR+W bit1's SCL rising edge (edge 7 of 8)
.measure tran bit_cnt_1_edge7 FIND v(xdut.x2.bit_cnt_1) AT=7.9e-05  $ bit_cnt_1 2us after ADDR+W bit1's SCL rising edge (edge 7 of 8)
.measure tran bit_cnt_2_edge7 FIND v(xdut.x2.bit_cnt_2) AT=7.9e-05  $ bit_cnt_2 2us after ADDR+W bit1's SCL rising edge (edge 7 of 8)
.measure tran lbp_edge7 FIND v(xdut.x2.last_bit_pending) AT=7.9e-05  $ last_bit_pending 2us after ADDR+W bit1's SCL rising edge (edge 7 of 8)
.measure tran bit_cnt_0_edge8 FIND v(xdut.x2.bit_cnt_0) AT=8.9e-05  $ bit_cnt_0 2us after ADDR+W bit0's SCL rising edge (edge 8 of 8)
.measure tran bit_cnt_1_edge8 FIND v(xdut.x2.bit_cnt_1) AT=8.9e-05  $ bit_cnt_1 2us after ADDR+W bit0's SCL rising edge (edge 8 of 8)
.measure tran bit_cnt_2_edge8 FIND v(xdut.x2.bit_cnt_2) AT=8.9e-05  $ bit_cnt_2 2us after ADDR+W bit0's SCL rising edge (edge 8 of 8)
.measure tran lbp_edge8 FIND v(xdut.x2.last_bit_pending) AT=8.9e-05  $ last_bit_pending 2us after ADDR+W bit0's SCL rising edge (edge 8 of 8)

* ---- diagnostic: SDA release slew (pull-up charge time) ----
.measure tran sda_release_trise TRIG v(P2) VAL=1.0 RISE=1 TARG v(P2) VAL=4.5 RISE=1  $ SDA release slew after START, before ADDR+W bit7

.control
  * ngspice only keeps the FULL time-history of a node available for a
  * later "write"/"plot"/vector-slice if it was explicitly "save"d before
  * "run" -- .measure works without this (it evaluates incrementally
  * during the run), which is why a real local run's .measure results
  * for these exact internal nodes succeeded while a later "write"/"plot"
  * of the same nodes (added without a matching "save") failed with
  * "no such vector". Save the full diagnostic node set up front so the
  * .raw file this generates actually contains their waveforms.
  save all

  run

  print rd_bit0 rd_bit1 rd_bit2 rd_bit3 rd_bit4 rd_bit5 rd_bit6 rd_bit7
  print ack0 ack1 ack2 ack3
  print busy_after_start addr_match_write rw_write addr_match_write_x1 addr_match_read rw_read addr_match_read_x1
  print tx_ADDR_W_bit7 tx_ADDR_W_bit6 tx_ADDR_W_bit5 tx_ADDR_W_bit4 tx_ADDR_W_bit3 tx_ADDR_W_bit2 tx_ADDR_W_bit1 tx_ADDR_W_bit0 tx_DATA_write_bit7 tx_DATA_write_bit6 tx_DATA_write_bit5 tx_DATA_write_bit4 tx_DATA_write_bit3 tx_DATA_write_bit2 tx_DATA_write_bit1 tx_DATA_write_bit0 tx_ADDR_R_bit7 tx_ADDR_R_bit6 tx_ADDR_R_bit5 tx_ADDR_R_bit4 tx_ADDR_R_bit3 tx_ADDR_R_bit2 tx_ADDR_R_bit1 tx_ADDR_R_bit0
  print shreg_0_write shreg_1_write shreg_2_write shreg_3_write shreg_4_write shreg_5_write shreg_6_write shreg_0_read shreg_1_read shreg_2_read shreg_3_read shreg_4_read shreg_5_read shreg_6_read
  print phase0_after_start phase1_after_start phase2_after_start bit_cnt_0_at_start_begin bit_cnt_1_at_start_begin bit_cnt_2_at_start_begin lbp_at_start_begin bit_cnt_0_before_bit7_edge bit_cnt_1_before_bit7_edge bit_cnt_2_before_bit7_edge lbp_before_bit7_edge bit_cnt_0_rst_300n phase_0_rst_300n bit_cnt_0_rst_550n phase_0_rst_550n bit_cnt_0_rst_650n phase_0_rst_650n bit_cnt_0_rst_900n phase_0_rst_900n bit_cnt_0_rst_1200n phase_0_rst_1200n bit_cnt_0_rst_1600n phase_0_rst_1600n fine_bitcnt0_t0 fine_ck_t0 fine_rstb_t0 fine_held_t0 fine_qn_t0 fine_raw_t0 fine_clr_t0 fine_d_t0 fine_qb_t0 fine_qm_t0 fine_net2_t0 fine_qs_t0 fine_net5_t0 fine_bitcnt0_t1 fine_ck_t1 fine_rstb_t1 fine_held_t1 fine_qn_t1 fine_raw_t1 fine_clr_t1 fine_d_t1 fine_qb_t1 fine_qm_t1 fine_net2_t1 fine_qs_t1 fine_net5_t1 fine_bitcnt0_t2 fine_ck_t2 fine_rstb_t2 fine_held_t2 fine_qn_t2 fine_raw_t2 fine_clr_t2 fine_d_t2 fine_qb_t2 fine_qm_t2 fine_net2_t2 fine_qs_t2 fine_net5_t2 fine_bitcnt0_t3 fine_ck_t3 fine_rstb_t3 fine_held_t3 fine_qn_t3 fine_raw_t3 fine_clr_t3 fine_d_t3 fine_qb_t3 fine_qm_t3 fine_net2_t3 fine_qs_t3 fine_net5_t3 fine_bitcnt0_t4 fine_ck_t4 fine_rstb_t4 fine_held_t4 fine_qn_t4 fine_raw_t4 fine_clr_t4 fine_d_t4 fine_qb_t4 fine_qm_t4 fine_net2_t4 fine_qs_t4 fine_net5_t4 fine_bitcnt0_t5 fine_ck_t5 fine_rstb_t5 fine_held_t5 fine_qn_t5 fine_raw_t5 fine_clr_t5 fine_d_t5 fine_qb_t5 fine_qm_t5 fine_net2_t5 fine_qs_t5 fine_net5_t5 fine_bitcnt0_t6 fine_ck_t6 fine_rstb_t6 fine_held_t6 fine_qn_t6 fine_raw_t6 fine_clr_t6 fine_d_t6 fine_qb_t6 fine_qm_t6 fine_net2_t6 fine_qs_t6 fine_net5_t6 fine_bitcnt0_t7 fine_ck_t7 fine_rstb_t7 fine_held_t7 fine_qn_t7 fine_raw_t7 fine_clr_t7 fine_d_t7 fine_qb_t7 fine_qm_t7 fine_net2_t7 fine_qs_t7 fine_net5_t7 fine_bitcnt0_t8 fine_ck_t8 fine_rstb_t8 fine_held_t8 fine_qn_t8 fine_raw_t8 fine_clr_t8 fine_d_t8 fine_qb_t8 fine_qm_t8 fine_net2_t8 fine_qs_t8 fine_net5_t8 fine_bitcnt0_t9 fine_ck_t9 fine_rstb_t9 fine_held_t9 fine_qn_t9 fine_raw_t9 fine_clr_t9 fine_d_t9 fine_qb_t9 fine_qm_t9 fine_net2_t9 fine_qs_t9 fine_net5_t9 fine_bitcnt0_t10 fine_ck_t10 fine_rstb_t10 fine_held_t10 fine_qn_t10 fine_raw_t10 fine_clr_t10 fine_d_t10 fine_qb_t10 fine_qm_t10 fine_net2_t10 fine_qs_t10 fine_net5_t10 fine_bitcnt0_t11 fine_ck_t11 fine_rstb_t11 fine_held_t11 fine_qn_t11 fine_raw_t11 fine_clr_t11 fine_d_t11 fine_qb_t11 fine_qm_t11 fine_net2_t11 fine_qs_t11 fine_net5_t11 fine_bitcnt0_t12 fine_ck_t12 fine_rstb_t12 fine_held_t12 fine_qn_t12 fine_raw_t12 fine_clr_t12 fine_d_t12 fine_qb_t12 fine_qm_t12 fine_net2_t12 fine_qs_t12 fine_net5_t12 fine_bitcnt0_t13 fine_ck_t13 fine_rstb_t13 fine_held_t13 fine_qn_t13 fine_raw_t13 fine_clr_t13 fine_d_t13 fine_qb_t13 fine_qm_t13 fine_net2_t13 fine_qs_t13 fine_net5_t13 fine_bitcnt0_t14 fine_ck_t14 fine_rstb_t14 fine_held_t14 fine_qn_t14 fine_raw_t14 fine_clr_t14 fine_d_t14 fine_qb_t14 fine_qm_t14 fine_net2_t14 fine_qs_t14 fine_net5_t14 fine_bitcnt0_t15 fine_ck_t15 fine_rstb_t15 fine_held_t15 fine_qn_t15 fine_raw_t15 fine_clr_t15 fine_d_t15 fine_qb_t15 fine_qm_t15 fine_net2_t15 fine_qs_t15 fine_net5_t15 fine_bitcnt0_t16 fine_ck_t16 fine_rstb_t16 fine_held_t16 fine_qn_t16 fine_raw_t16 fine_clr_t16 fine_d_t16 fine_qb_t16 fine_qm_t16 fine_net2_t16 fine_qs_t16 fine_net5_t16 fine_bitcnt0_t17 fine_ck_t17 fine_rstb_t17 fine_held_t17 fine_qn_t17 fine_raw_t17 fine_clr_t17 fine_d_t17 fine_qb_t17 fine_qm_t17 fine_net2_t17 fine_qs_t17 fine_net5_t17 fine_bitcnt0_t18 fine_ck_t18 fine_rstb_t18 fine_held_t18 fine_qn_t18 fine_raw_t18 fine_clr_t18 fine_d_t18 fine_qb_t18 fine_qm_t18 fine_net2_t18 fine_qs_t18 fine_net5_t18 fine_bitcnt0_t19 fine_ck_t19 fine_rstb_t19 fine_held_t19 fine_qn_t19 fine_raw_t19 fine_clr_t19 fine_d_t19 fine_qb_t19 fine_qm_t19 fine_net2_t19 fine_qs_t19 fine_net5_t19 fine_bitcnt0_t20 fine_ck_t20 fine_rstb_t20 fine_held_t20 fine_qn_t20 fine_raw_t20 fine_clr_t20 fine_d_t20 fine_qb_t20 fine_qm_t20 fine_net2_t20 fine_qs_t20 fine_net5_t20 bc0_x1 bc0_x2 bc0_x3 bc0_x4 bc0_x5 bc0_x6 bc0_x7 bc0_x8 bc1_x1 bc1_x2 bc1_x3 bc1_x4 bc1_x5 bc1_x6 bc2_x1 bc2_x2 bc2_x3 bc2_x4 d004_x1 lbp_x1 ck_x1 d_066_e1 d_100_e1 d_111_e1 d_094_e1 d_085_e1 d_098_e1 d_099_e1 d_110_e1 bc0_e1 bc0_qb_e1 d_066_mid d_100_mid d_111_mid d_094_mid d_085_mid d_098_mid d_099_mid d_110_mid bc0_mid bc0_qb_mid d_066_e2pre d_100_e2pre d_111_e2pre d_094_e2pre d_085_e2pre d_098_e2pre d_099_e2pre d_110_e2pre bc0_e2pre bc0_qb_e2pre tl_scl_row2_x1 tl_scl_row2_x2 tl_scl_row2_x3 tl_scl_row2_x4 tl_016_x1 tl_016_x2 tl_016_x3 tl_016_x4 tl_rst_scl_domain_held_x1 tl_rst_scl_domain_held_x2 tl_rst_scl_domain_held_x3 tl_rst_scl_domain_held_x4 tl_rst_stretch_qn_x1 tl_rst_stretch_qn_x2 tl_rst_stretch_qn_x3 tl_rst_stretch_qn_x4 tl_143_x1 tl_143_x2 tl_143_x3 tl_143_x4 tl_144_x1 tl_144_x2 tl_144_x3 tl_144_x4 tl_156_x1 tl_156_x2 tl_156_x3 tl_156_x4 tl_156__row1_x1 tl_156__row1_x2 tl_156__row1_x3 tl_156__row1_x4 g2_143_x1 g2_143_x2 g2_143_x3 g2_143_x4 g2_143_x5 g2_143_x6 g2_143_x7 g2_143_x8 g2_143_x9 g2_143_x10 g2_143_x11 g2_143_x12 g2_143_x13 g2_143_x14 g2_143_x15 g2_143_x16 g2_144_x1 g2_144_x2 g2_144_x3 g2_144_x4 g2_144_x5 g2_144_x6 g2_144_x7 g2_144_x8 g2_144_x9 g2_144_x10 g2_144_x11 g2_144_x12 g2_144_x13 g2_144_x14 g2_144_x15 g2_144_x16 g2_rst_scl_domain_held_x1 g2_rst_scl_domain_held_x2 g2_rst_scl_domain_held_x3 g2_rst_scl_domain_held_x4 g2_rst_scl_domain_held_x5 g2_rst_scl_domain_held_x6 g2_rst_scl_domain_held_x7 g2_rst_scl_domain_held_x8 g2_rst_scl_domain_held_x9 g2_rst_scl_domain_held_x10 g2_rst_scl_domain_held_x11 g2_rst_scl_domain_held_x12 g2_rst_scl_domain_held_x13 g2_rst_scl_domain_held_x14 g2_rst_scl_domain_held_x15 g2_rst_scl_domain_held_x16 g2_rst_stretch_qn_x1 g2_rst_stretch_qn_x2 g2_rst_stretch_qn_x3 g2_rst_stretch_qn_x4 g2_rst_stretch_qn_x5 g2_rst_stretch_qn_x6 g2_rst_stretch_qn_x7 g2_rst_stretch_qn_x8 g2_rst_stretch_qn_x9 g2_rst_stretch_qn_x10 g2_rst_stretch_qn_x11 g2_rst_stretch_qn_x12 g2_rst_stretch_qn_x13 g2_rst_stretch_qn_x14 g2_rst_stretch_qn_x15 g2_rst_stretch_qn_x16 g2_016_x1 g2_016_x2 g2_016_x3 g2_016_x4 g2_016_x5 g2_016_x6 g2_016_x7 g2_016_x8 g2_016_x9 g2_016_x10 g2_016_x11 g2_016_x12 g2_016_x13 g2_016_x14 g2_016_x15 g2_016_x16
  print last_bit_pending_write phase_0_write phase_1_write phase_2_write last_bit_pending_read phase_0_read phase_1_read phase_2_read
  print bit_cnt_0_edge1 bit_cnt_1_edge1 bit_cnt_2_edge1 lbp_edge1 bit_cnt_0_edge2 bit_cnt_1_edge2 bit_cnt_2_edge2 lbp_edge2 bit_cnt_0_edge3 bit_cnt_1_edge3 bit_cnt_2_edge3 lbp_edge3 bit_cnt_0_edge4 bit_cnt_1_edge4 bit_cnt_2_edge4 lbp_edge4 bit_cnt_0_edge5 bit_cnt_1_edge5 bit_cnt_2_edge5 lbp_edge5 bit_cnt_0_edge6 bit_cnt_1_edge6 bit_cnt_2_edge6 lbp_edge6 bit_cnt_0_edge7 bit_cnt_1_edge7 bit_cnt_2_edge7 lbp_edge7 bit_cnt_0_edge8 bit_cnt_1_edge8 bit_cnt_2_edge8 lbp_edge8
  print sda_release_trise

  * rx_data after the write transaction's ACK (expect 0xA5):
  * bit0..7 = ['NC_OUT11', 'NC_OUT12', 'NC_OUT13', 'NC_OUT14', 'NC_OUT6', 'NC_OUT5', 'NC_OUT4', 'NC_OUT3']
  print v(xdut.NC_OUT11) v(xdut.NC_OUT12) v(xdut.NC_OUT13) v(xdut.NC_OUT14) v(xdut.NC_OUT6) v(xdut.NC_OUT5) v(xdut.NC_OUT4) v(xdut.NC_OUT3)

  set filetype=ascii
  * (2026-09-02: dropped the old scl_row0/scl_row1/_079_/_092_/_103_/
  * _104_/_059_/_061_ probes here -- those were auto-generated Yosys net
  * names from the pre-v5 synthesis and no longer exist/no longer refer
  * to the same nodes after resynthesis; comparator-chain logic was
  * already confirmed correct at the netlist level, so they're not
  * needed for ongoing verification. bit_cnt_0/1/2, phase_0/1/2,
  * last_bit_pending, shreg_0-6 are stable RTL-level register names and
  * kept.)
  write tb_chip_i2c.raw v(P1) v(P2) v(P15) v(xdut.NC_OUT11) v(xdut.NC_OUT12) v(xdut.NC_OUT13) v(xdut.NC_OUT14) v(xdut.NC_OUT6) v(xdut.NC_OUT5) v(xdut.NC_OUT4) v(xdut.NC_OUT3) v(xdut.NC_CORE_busy) v(xdut.NC_CORE_addr_match) v(xdut.NC_CORE_rw) i(vvdd) v(xdut.x2.last_bit_pending) v(xdut.x2.phase_0) v(xdut.x2.phase_1) v(xdut.x2.phase_2) v(xdut.x2.shreg_0) v(xdut.x2.shreg_1) v(xdut.x2.shreg_2) v(xdut.x2.shreg_3) v(xdut.x2.shreg_4) v(xdut.x2.shreg_5) v(xdut.x2.shreg_6) v(xdut.x2.bit_cnt_0) v(xdut.x2.bit_cnt_1) v(xdut.x2.bit_cnt_2)

  * interactive viewing (see tb_ring_osc.spice's own note: ignored
  * harmlessly in -b batch mode without a display; run without -b, or
  * `ngspice -b tb_chip_i2c.spice` then load tb_chip_i2c.raw in any
  * viewer, e.g. `ngspice -r tb_chip_i2c.raw` + `plot` at the prompt).
  plot v(P1) v(P2)
  plot v(P15)
  plot v(xdut.NC_OUT11) v(xdut.NC_OUT12) v(xdut.NC_OUT13) v(xdut.NC_OUT14) v(xdut.NC_OUT6) v(xdut.NC_OUT5) v(xdut.NC_OUT4) v(xdut.NC_OUT3)
  plot v(xdut.NC_CORE_busy) v(xdut.NC_CORE_addr_match) v(xdut.NC_CORE_rw)

  * ---- DFFRB slave-hold race diagnostic (bit_cnt_0's flop, x_505_) ----
  * bit_cnt_0 (Q) was seen to collapse from 5V to ~0V exactly in sync with
  * CK's own falling edge between edge1(17us) and edge2(27us) instead of
  * holding through the whole low phase. The earlier point-sample sweep
  * only showed the value AFTER the collapse had already completed (one
  * full 1us sample past it); these plots zoom into the actual transition
  * window (CK is known to fall somewhere between t=21.5us and t=22.5us)
  * so the real shape of the glitch -- fast digital race vs. slow settle,
  * which node moves first, whether QM/net2 (master) stay clean while
  * QS/net5 (slave) alone glitch -- can be read directly off the traces.
  * Widen/narrow with another `xlimit a b` + `plot ...` at the ngspice
  * prompt once the approximate glitch time is visible.
  plot v(xdut.x2._156__row1) v(xdut.x2.bit_cnt_0) xlimit 2.1e-05 2.3e-05
  plot v(xdut.x2.x_505_.qm) v(xdut.x2.x_505_.net2) xlimit 2.1e-05 2.3e-05
  plot v(xdut.x2.x_505_.qs) v(xdut.x2.x_505_.net5) xlimit 2.1e-05 2.3e-05
  plot v(xdut.x2._212_) v(xdut.x2._066_) xlimit 2.1e-05 2.3e-05
  plot v(xdut.x2._156__row1) v(xdut.x2.x_505_.qm) v(xdut.x2.x_505_.qs) v(xdut.x2._212_) v(xdut.x2.bit_cnt_0) xlimit 2.1e-05 2.3e-05
.endc

.end
