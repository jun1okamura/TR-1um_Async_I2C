* tb_chip_i2c_v10.spice -- auto-generated by script/gen_chip_tb_v10.py
* DO NOT hand-edit -- regenerate instead.
*
* Whole-V10-chip (RING_OSC excluded) I2C WRITE-then-READ testbench at
* SCL=100kHz, using the real TR-1um transistor models and ngspice/
* tr_1um_i2c_slave_async_v10_sim_ready.spice (the LVS-confirmed V10
* chip netlist, M->X + NMOSE->MNE converted -- see script/gen_chip_sim_
* ready_v10.py). Same protocol as V9's own tb_chip_i2c.spice, but V10's
* own pad-pairing-aware terminal reassignment (108.57) means TX_PADS/
* RX_NETS differ from V9's -- see this script's own module docstring.
*
* Protocol:
*   WRITE: S, ADDR+W(0xA0), ACK, DATA=0xA5, ACK, P
*   READ : S, ADDR+R(0xA1), ACK, DATA=0x3C (slave-driven), NACK, P
*
* DIS (P7) held HIGH the whole run (Hi-Z / tx_data-input mode) so the 8
* shared tx/rx pads never contend with this testbench's own TX drive --
* rx_data is instead observed at each pad's own internal receiver net
* (NC_OUT.. ), which reflects the pad regardless of DIS. tx_data is
* held at 0x3C for the whole run (only consumed during the read).

.include '~/Dropbox/91_OpenPDK/TR-1um/libs.tech/spice/models/ip62_models'
.include '../tr_1um_i2c_slave_async_v10_sim_ready.spice'

.param vdd=5.0

vvdd VDD 0 DC 5.0
vvss VSS 0 DC 0

* RSTN: low for 500ns (power-on reset), then a fast edge to VDD,
* held for the rest of the run -- real async reset via each DFFRB's own
* RSTB pin.
vrstn P15 0 PWL(0 0 5e-07 0 6e-07 5.0)

* DIS: held high the whole run (see docstring).
vdis P7 0 DC 5.0

* P9/P10 (RING_OSC.OUTD/OUT in the full chip -- unused and otherwise
* floating here, since RING_OSC is excluded from this netlist). Tied to
* VSS via a large resistor purely for SPICE DC-path/convergence safety.
rp9 P9 VSS 1G
rp10 P10 VSS 1G

* tx_data (bit0..7 = ['P4', 'P12', 'P14', 'P5', 'P6', 'P3', 'P11', 'P13']), held at 0x3C for the whole run.
vtx0 P4 0 DC 0.0
vtx1 P12 0 DC 0.0
vtx2 P14 0 DC 5.0
vtx3 P5 0 DC 5.0
vtx4 P6 0 DC 5.0
vtx5 P3 0 DC 5.0
vtx6 P11 0 DC 0.0
vtx7 P13 0 DC 0.0

* SCL: master clock, 100kHz during bus activity (idle high otherwise).
vscl P1 0 PWL(0 5.000 2e-06 5.000 1.19e-05 5.000 1.2e-05 0.000 1.69e-05 0.000 1.7e-05 5.000 2.19e-05 5.000 2.2e-05 0.000 2.69e-05 0.000 2.7e-05 5.000 3.19e-05 5.000 3.2e-05 0.000 3.69e-05 0.000 3.7e-05 5.000 4.19e-05 5.000 4.2e-05 0.000 4.69e-05 0.000 4.7e-05 5.000 5.19e-05 5.000 5.2e-05 0.000 5.69e-05 0.000 5.7e-05 5.000 6.19e-05 5.000 6.2e-05 0.000 6.69e-05 0.000 6.7e-05 5.000 7.19e-05 5.000 7.2e-05 0.000 7.69e-05 0.000 7.7e-05 5.000 8.19e-05 5.000 8.2e-05 0.000 8.69e-05 0.000 8.7e-05 5.000 9.19e-05 5.000 9.2e-05 0.000 9.69e-05 0.000 9.7e-05 5.000 0.0001019 5.000 0.000102 0.000 0.0001069 0.000 0.000107 5.000 0.0001119 5.000 0.000112 0.000 0.0001169 0.000 0.000117 5.000 0.0001219 5.000 0.000122 0.000 0.0001269 0.000 0.000127 5.000 0.0001319 5.000 0.000132 0.000 0.0001369 0.000 0.000137 5.000 0.0001419 5.000 0.000142 0.000 0.0001469 0.000 0.000147 5.000 0.0001519 5.000 0.000152 0.000 0.0001569 0.000 0.000157 5.000 0.0001619 5.000 0.000162 0.000 0.0001669 0.000 0.000167 5.000 0.0001719 5.000 0.000172 0.000 0.0001769 0.000 0.000177 5.000 0.0001819 5.000 0.000182 0.000 0.0001869 0.000 0.000187 5.000 0.0001919 5.000 0.000192 0.000 0.0001969 0.000 0.000197 5.000 0.000207 5.000 0.000212 5.000 0.0002219 5.000 0.000222 0.000 0.0002269 0.000 0.000227 5.000 0.0002319 5.000 0.000232 0.000 0.0002369 0.000 0.000237 5.000 0.0002419 5.000 0.000242 0.000 0.0002469 0.000 0.000247 5.000 0.0002519 5.000 0.000252 0.000 0.0002569 0.000 0.000257 5.000 0.0002619 5.000 0.000262 0.000 0.0002669 0.000 0.000267 5.000 0.0002719 5.000 0.000272 0.000 0.0002769 0.000 0.000277 5.000 0.0002819 5.000 0.000282 0.000 0.0002869 0.000 0.000287 5.000 0.0002919 5.000 0.000292 0.000 0.0002969 0.000 0.000297 5.000 0.0003019 5.000 0.000302 0.000 0.0003069 0.000 0.000307 5.000 0.0003119 5.000 0.000312 0.000 0.0003169 0.000 0.000317 5.000 0.0003219 5.000 0.000322 0.000 0.0003269 0.000 0.000327 5.000 0.0003319 5.000 0.000332 0.000 0.0003369 0.000 0.000337 5.000 0.0003419 5.000 0.000342 0.000 0.0003469 0.000 0.000347 5.000 0.0003519 5.000 0.000352 0.000 0.0003569 0.000 0.000357 5.000 0.0003619 5.000 0.000362 0.000 0.0003669 0.000 0.000367 5.000 0.0003719 5.000 0.000372 0.000 0.0003769 0.000 0.000377 5.000 0.0003819 5.000 0.000382 0.000 0.0003869 0.000 0.000387 5.000 0.0003919 5.000 0.000392 0.000 0.0003969 0.000 0.000397 5.000 0.0004019 5.000 0.000402 0.000 0.0004069 0.000 0.000407 5.000 0.000417 5.000 0.000422 5.000)

* SDA open-drain bus: this testbench's own master drive (voltage-
* controlled switch to VSS, gated by SDA_CTRL) in parallel with an
* external 10k pull-up to VDD (chip itself has no on-chip SDA
* pull-up) and the DUT's own internal SDA driver (already part of the
* DUT netlist).
vsda_ctrl SDA_CTRL 0 PWL(0 0.000 2e-06 0.000 6.9e-06 0.000 7e-06 5.000 1.22e-05 5.000 1.23e-05 0.000 2.22e-05 0.000 2.23e-05 5.000 3.22e-05 5.000 3.23e-05 0.000 4.22e-05 0.000 4.23e-05 5.000 5.23e-05 5.000 6.23e-05 5.000 7.23e-05 5.000 8.23e-05 5.000 9.22e-05 5.000 9.23e-05 0.000 0.0001023 0.000 0.0001122 0.000 0.0001123 5.000 0.0001222 5.000 0.0001223 0.000 0.0001322 0.000 0.0001323 5.000 0.0001423 5.000 0.0001522 5.000 0.0001523 0.000 0.0001622 0.000 0.0001623 5.000 0.0001722 5.000 0.0001723 0.000 0.0001823 0.000 0.0001922 0.000 0.0001923 5.000 0.0002019 5.000 0.000202 0.000 0.000207 0.000 0.000212 0.000 0.0002169 0.000 0.000217 5.000 0.0002222 5.000 0.0002223 0.000 0.0002322 0.000 0.0002323 5.000 0.0002422 5.000 0.0002423 0.000 0.0002522 0.000 0.0002523 5.000 0.0002623 5.000 0.0002723 5.000 0.0002823 5.000 0.0002922 5.000 0.0002923 0.000 0.0003023 0.000 0.0003123 0.000 0.0003223 0.000 0.0003323 0.000 0.0003423 0.000 0.0003523 0.000 0.0003623 0.000 0.0003723 0.000 0.0003823 0.000 0.0003923 0.000 0.0004022 0.000 0.0004023 5.000 0.0004119 5.000 0.000412 0.000 0.000417 0.000 0.000422 0.000)
.model SDASW SW(RON=10 ROFF=1MEG VT=2.5 VH=0.3)
ssda P2 0 SDA_CTRL 0 SDASW
rpu P2 VDD 10k

* DUT instantiation -- pin order read directly from ngspice/tr_1um_i2c_
* slave_async_v10_sim_ready.spice's own '.subckt tr_1um_i2c_slave_async
* ...' line (not hand-typed), see read_top_pin_order().
xdut P1 P2 P3 P4 P5 P6 P7 VSS P9 P10 P11 P12 P13 P14 P15 VDD tr_1um_i2c_slave_async

.tran 50n 0.000424

* ---- sample points: read-data bits (mid SCL-high window of each of
* the 8 slave-driven bits during the read transaction) ----
.measure tran rd_bit0 FIND v(P2) AT=0.0003195  $ expect ~0V (bit=0)
.measure tran rd_bit1 FIND v(P2) AT=0.0003295  $ expect ~0V (bit=0)
.measure tran rd_bit2 FIND v(P2) AT=0.0003395  $ expect ~VDD (bit=1)
.measure tran rd_bit3 FIND v(P2) AT=0.0003495  $ expect ~VDD (bit=1)
.measure tran rd_bit4 FIND v(P2) AT=0.0003595  $ expect ~VDD (bit=1)
.measure tran rd_bit5 FIND v(P2) AT=0.0003695  $ expect ~VDD (bit=1)
.measure tran rd_bit6 FIND v(P2) AT=0.0003795  $ expect ~0V (bit=0)
.measure tran rd_bit7 FIND v(P2) AT=0.0003895  $ expect ~0V (bit=0)

* ---- ACK sample points (expect ~0V = ACK asserted) ----
.measure tran ack0 FIND v(P2) AT=9.95e-05  $ ACK (slave, address/write)
.measure tran ack1 FIND v(P2) AT=0.0001895  $ ACK (slave, data)
.measure tran ack2 FIND v(P2) AT=0.0003095  $ ACK (slave, address/read)
.measure tran ack3 FIND v(P2) AT=0.0003995  $ NACK (master, ends read)

* ---- diagnostic: internal core state (busy/addr_match/rw), to
* localize a non-responsive-bus result ----
.measure tran busy_after_start FIND v(xdut.NC_CORE_busy) AT=9.5e-06  $ expect ~VDD (busy asserted shortly after START)
.measure tran addr_match_write FIND v(xdut.NC_CORE_addr_match) AT=0.0001018  $ expect ~VDD if address 0x50 matched (ACK (slave, address/write))
.measure tran rw_write FIND v(xdut.NC_CORE_rw) AT=0.0001018  $ expect ~0V (write)
.measure tran addr_match_write_x1 WHEN v(xdut.NC_CORE_addr_match)=2.5 RISE=1  $ addr_match rise #1 (ACK (slave, address/write))
.measure tran addr_match_read FIND v(xdut.NC_CORE_addr_match) AT=0.0003118  $ expect ~VDD if address 0x50 matched (ACK (slave, address/read))
.measure tran rw_read FIND v(xdut.NC_CORE_rw) AT=0.0003118  $ expect ~VDD (read)
.measure tran addr_match_read_x1 WHEN v(xdut.NC_CORE_addr_match)=2.5 RISE=2  $ addr_match rise #2 (ACK (slave, address/read))

* ---- diagnostic: this generator's OWN driven bus level self-check
* (independent of the DUT) for every master-driven address/data bit ----
.measure tran tx_ADDR_W_bit7 FIND v(P2) AT=1.95e-05  $ self-check: this generator's OWN driven bus level, ADDR+W bit7 (expect ~VDD (bit=1))
.measure tran tx_ADDR_W_bit6 FIND v(P2) AT=2.95e-05  $ self-check: this generator's OWN driven bus level, ADDR+W bit6 (expect ~0V (bit=0))
.measure tran tx_ADDR_W_bit5 FIND v(P2) AT=3.95e-05  $ self-check: this generator's OWN driven bus level, ADDR+W bit5 (expect ~VDD (bit=1))
.measure tran tx_ADDR_W_bit4 FIND v(P2) AT=4.95e-05  $ self-check: this generator's OWN driven bus level, ADDR+W bit4 (expect ~0V (bit=0))
.measure tran tx_ADDR_W_bit3 FIND v(P2) AT=5.95e-05  $ self-check: this generator's OWN driven bus level, ADDR+W bit3 (expect ~0V (bit=0))
.measure tran tx_ADDR_W_bit2 FIND v(P2) AT=6.95e-05  $ self-check: this generator's OWN driven bus level, ADDR+W bit2 (expect ~0V (bit=0))
.measure tran tx_ADDR_W_bit1 FIND v(P2) AT=7.95e-05  $ self-check: this generator's OWN driven bus level, ADDR+W bit1 (expect ~0V (bit=0))
.measure tran tx_ADDR_W_bit0 FIND v(P2) AT=8.95e-05  $ self-check: this generator's OWN driven bus level, ADDR+W bit0 (expect ~0V (bit=0))
.measure tran tx_DATA_write_bit7 FIND v(P2) AT=0.0001095  $ self-check: this generator's OWN driven bus level, DATA (write) bit7 (expect ~VDD (bit=1))
.measure tran tx_DATA_write_bit6 FIND v(P2) AT=0.0001195  $ self-check: this generator's OWN driven bus level, DATA (write) bit6 (expect ~0V (bit=0))
.measure tran tx_DATA_write_bit5 FIND v(P2) AT=0.0001295  $ self-check: this generator's OWN driven bus level, DATA (write) bit5 (expect ~VDD (bit=1))
.measure tran tx_DATA_write_bit4 FIND v(P2) AT=0.0001395  $ self-check: this generator's OWN driven bus level, DATA (write) bit4 (expect ~0V (bit=0))
.measure tran tx_DATA_write_bit3 FIND v(P2) AT=0.0001495  $ self-check: this generator's OWN driven bus level, DATA (write) bit3 (expect ~0V (bit=0))
.measure tran tx_DATA_write_bit2 FIND v(P2) AT=0.0001595  $ self-check: this generator's OWN driven bus level, DATA (write) bit2 (expect ~VDD (bit=1))
.measure tran tx_DATA_write_bit1 FIND v(P2) AT=0.0001695  $ self-check: this generator's OWN driven bus level, DATA (write) bit1 (expect ~0V (bit=0))
.measure tran tx_DATA_write_bit0 FIND v(P2) AT=0.0001795  $ self-check: this generator's OWN driven bus level, DATA (write) bit0 (expect ~VDD (bit=1))
.measure tran tx_ADDR_R_bit7 FIND v(P2) AT=0.0002295  $ self-check: this generator's OWN driven bus level, ADDR+R bit7 (expect ~VDD (bit=1))
.measure tran tx_ADDR_R_bit6 FIND v(P2) AT=0.0002395  $ self-check: this generator's OWN driven bus level, ADDR+R bit6 (expect ~0V (bit=0))
.measure tran tx_ADDR_R_bit5 FIND v(P2) AT=0.0002495  $ self-check: this generator's OWN driven bus level, ADDR+R bit5 (expect ~VDD (bit=1))
.measure tran tx_ADDR_R_bit4 FIND v(P2) AT=0.0002595  $ self-check: this generator's OWN driven bus level, ADDR+R bit4 (expect ~0V (bit=0))
.measure tran tx_ADDR_R_bit3 FIND v(P2) AT=0.0002695  $ self-check: this generator's OWN driven bus level, ADDR+R bit3 (expect ~0V (bit=0))
.measure tran tx_ADDR_R_bit2 FIND v(P2) AT=0.0002795  $ self-check: this generator's OWN driven bus level, ADDR+R bit2 (expect ~0V (bit=0))
.measure tran tx_ADDR_R_bit1 FIND v(P2) AT=0.0002895  $ self-check: this generator's OWN driven bus level, ADDR+R bit1 (expect ~0V (bit=0))
.measure tran tx_ADDR_R_bit0 FIND v(P2) AT=0.0002995  $ self-check: this generator's OWN driven bus level, ADDR+R bit0 (expect ~VDD (bit=1))

* ---- diagnostic: internal address shift-register (shreg_0..shreg_6,
* inside xdut.x2 = i2c_slave_async_nrow_fm) snapshot right after each
* address byte's last-bit SCL edge ----
.measure tran shreg_0_write FIND v(xdut.x2.shreg_0) AT=8.9e-05  $ internal address shift-reg bit, right after the ADDR+W last-bit SCL edge
.measure tran shreg_1_write FIND v(xdut.x2.shreg_1) AT=8.9e-05  $ internal address shift-reg bit, right after the ADDR+W last-bit SCL edge
.measure tran shreg_2_write FIND v(xdut.x2.shreg_2) AT=8.9e-05  $ internal address shift-reg bit, right after the ADDR+W last-bit SCL edge
.measure tran shreg_3_write FIND v(xdut.x2.shreg_3) AT=8.9e-05  $ internal address shift-reg bit, right after the ADDR+W last-bit SCL edge
.measure tran shreg_4_write FIND v(xdut.x2.shreg_4) AT=8.9e-05  $ internal address shift-reg bit, right after the ADDR+W last-bit SCL edge
.measure tran shreg_5_write FIND v(xdut.x2.shreg_5) AT=8.9e-05  $ internal address shift-reg bit, right after the ADDR+W last-bit SCL edge
.measure tran shreg_6_write FIND v(xdut.x2.shreg_6) AT=8.9e-05  $ internal address shift-reg bit, right after the ADDR+W last-bit SCL edge
.measure tran shreg_0_read FIND v(xdut.x2.shreg_0) AT=0.000299  $ internal address shift-reg bit, right after the ADDR+R last-bit SCL edge
.measure tran shreg_1_read FIND v(xdut.x2.shreg_1) AT=0.000299  $ internal address shift-reg bit, right after the ADDR+R last-bit SCL edge
.measure tran shreg_2_read FIND v(xdut.x2.shreg_2) AT=0.000299  $ internal address shift-reg bit, right after the ADDR+R last-bit SCL edge
.measure tran shreg_3_read FIND v(xdut.x2.shreg_3) AT=0.000299  $ internal address shift-reg bit, right after the ADDR+R last-bit SCL edge
.measure tran shreg_4_read FIND v(xdut.x2.shreg_4) AT=0.000299  $ internal address shift-reg bit, right after the ADDR+R last-bit SCL edge
.measure tran shreg_5_read FIND v(xdut.x2.shreg_5) AT=0.000299  $ internal address shift-reg bit, right after the ADDR+R last-bit SCL edge
.measure tran shreg_6_read FIND v(xdut.x2.shreg_6) AT=0.000299  $ internal address shift-reg bit, right after the ADDR+R last-bit SCL edge

* ---- diagnostic: phase-FSM (phase_0/1/2) after START, and bit_cnt/
* last_bit_pending across reset release ----
.measure tran phase0_after_start FIND v(xdut.x2.phase_0) AT=9.5e-06  $ phase bit0 shortly after START
.measure tran phase1_after_start FIND v(xdut.x2.phase_1) AT=9.5e-06  $ phase bit1 shortly after START
.measure tran phase2_after_start FIND v(xdut.x2.phase_2) AT=9.5e-06  $ phase bit2 shortly after START
.measure tran bit_cnt_0_at_start_begin FIND v(xdut.x2.bit_cnt_0) AT=2.001e-06  $ bit_cnt_0 at_start_begin
.measure tran bit_cnt_1_at_start_begin FIND v(xdut.x2.bit_cnt_1) AT=2.001e-06  $ bit_cnt_1 at_start_begin
.measure tran bit_cnt_2_at_start_begin FIND v(xdut.x2.bit_cnt_2) AT=2.001e-06  $ bit_cnt_2 at_start_begin
.measure tran lbp_at_start_begin FIND v(xdut.x2.last_bit_pending) AT=2.001e-06  $ last_bit_pending at_start_begin
.measure tran bit_cnt_0_before_bit7_edge FIND v(xdut.x2.bit_cnt_0) AT=1.22e-05  $ bit_cnt_0 before_bit7_edge
.measure tran bit_cnt_1_before_bit7_edge FIND v(xdut.x2.bit_cnt_1) AT=1.22e-05  $ bit_cnt_1 before_bit7_edge
.measure tran bit_cnt_2_before_bit7_edge FIND v(xdut.x2.bit_cnt_2) AT=1.22e-05  $ bit_cnt_2 before_bit7_edge
.measure tran lbp_before_bit7_edge FIND v(xdut.x2.last_bit_pending) AT=1.22e-05  $ last_bit_pending before_bit7_edge
.measure tran bit_cnt_0_rst_300n FIND v(xdut.x2.bit_cnt_0) AT=3e-07  $ bit_cnt_0 at rst_300n
.measure tran phase_0_rst_300n FIND v(xdut.x2.phase_0) AT=3e-07  $ phase_0 at rst_300n (for comparison)
.measure tran bit_cnt_0_rst_550n FIND v(xdut.x2.bit_cnt_0) AT=5.5e-07  $ bit_cnt_0 at rst_550n
.measure tran phase_0_rst_550n FIND v(xdut.x2.phase_0) AT=5.5e-07  $ phase_0 at rst_550n (for comparison)
.measure tran bit_cnt_0_rst_650n FIND v(xdut.x2.bit_cnt_0) AT=6.5e-07  $ bit_cnt_0 at rst_650n
.measure tran phase_0_rst_650n FIND v(xdut.x2.phase_0) AT=6.5e-07  $ phase_0 at rst_650n (for comparison)
.measure tran bit_cnt_0_rst_900n FIND v(xdut.x2.bit_cnt_0) AT=9e-07  $ bit_cnt_0 at rst_900n
.measure tran phase_0_rst_900n FIND v(xdut.x2.phase_0) AT=9e-07  $ phase_0 at rst_900n (for comparison)
.measure tran bit_cnt_0_rst_1200n FIND v(xdut.x2.bit_cnt_0) AT=1.2e-06  $ bit_cnt_0 at rst_1200n
.measure tran phase_0_rst_1200n FIND v(xdut.x2.phase_0) AT=1.2e-06  $ phase_0 at rst_1200n (for comparison)
.measure tran bit_cnt_0_rst_1600n FIND v(xdut.x2.bit_cnt_0) AT=1.6e-06  $ bit_cnt_0 at rst_1600n
.measure tran phase_0_rst_1600n FIND v(xdut.x2.phase_0) AT=1.6e-06  $ phase_0 at rst_1600n (for comparison)

* ---- diagnostic: comparator-chain nodes (last_bit_pending/phase_0-2)
* right after each address byte's last-bit SCL edge ----
.measure tran last_bit_pending_write FIND v(xdut.x2.last_bit_pending) AT=8.9e-05  $ comparator-chain node, right after the ADDR+W last-bit SCL edge
.measure tran phase_0_write FIND v(xdut.x2.phase_0) AT=8.9e-05  $ comparator-chain node, right after the ADDR+W last-bit SCL edge
.measure tran phase_1_write FIND v(xdut.x2.phase_1) AT=8.9e-05  $ comparator-chain node, right after the ADDR+W last-bit SCL edge
.measure tran phase_2_write FIND v(xdut.x2.phase_2) AT=8.9e-05  $ comparator-chain node, right after the ADDR+W last-bit SCL edge
.measure tran last_bit_pending_read FIND v(xdut.x2.last_bit_pending) AT=0.000299  $ comparator-chain node, right after the ADDR+R last-bit SCL edge
.measure tran phase_0_read FIND v(xdut.x2.phase_0) AT=0.000299  $ comparator-chain node, right after the ADDR+R last-bit SCL edge
.measure tran phase_1_read FIND v(xdut.x2.phase_1) AT=0.000299  $ comparator-chain node, right after the ADDR+R last-bit SCL edge
.measure tran phase_2_read FIND v(xdut.x2.phase_2) AT=0.000299  $ comparator-chain node, right after the ADDR+R last-bit SCL edge

* ---- diagnostic: bit_cnt_0/1/2 + last_bit_pending trajectory at every
* ADDR+W bit edge (edge1..edge8) ----
.measure tran bit_cnt_0_edge1 FIND v(xdut.x2.bit_cnt_0) AT=1.9e-05  $ bit_cnt_0 2us after ADDR+W bit7's SCL rising edge (edge 1 of 8)
.measure tran bit_cnt_1_edge1 FIND v(xdut.x2.bit_cnt_1) AT=1.9e-05  $ bit_cnt_1 2us after ADDR+W bit7's SCL rising edge (edge 1 of 8)
.measure tran bit_cnt_2_edge1 FIND v(xdut.x2.bit_cnt_2) AT=1.9e-05  $ bit_cnt_2 2us after ADDR+W bit7's SCL rising edge (edge 1 of 8)
.measure tran lbp_edge1 FIND v(xdut.x2.last_bit_pending) AT=1.9e-05  $ last_bit_pending 2us after ADDR+W bit7's SCL rising edge (edge 1 of 8)
.measure tran bit_cnt_0_edge2 FIND v(xdut.x2.bit_cnt_0) AT=2.9e-05  $ bit_cnt_0 2us after ADDR+W bit6's SCL rising edge (edge 2 of 8)
.measure tran bit_cnt_1_edge2 FIND v(xdut.x2.bit_cnt_1) AT=2.9e-05  $ bit_cnt_1 2us after ADDR+W bit6's SCL rising edge (edge 2 of 8)
.measure tran bit_cnt_2_edge2 FIND v(xdut.x2.bit_cnt_2) AT=2.9e-05  $ bit_cnt_2 2us after ADDR+W bit6's SCL rising edge (edge 2 of 8)
.measure tran lbp_edge2 FIND v(xdut.x2.last_bit_pending) AT=2.9e-05  $ last_bit_pending 2us after ADDR+W bit6's SCL rising edge (edge 2 of 8)
.measure tran bit_cnt_0_edge3 FIND v(xdut.x2.bit_cnt_0) AT=3.9e-05  $ bit_cnt_0 2us after ADDR+W bit5's SCL rising edge (edge 3 of 8)
.measure tran bit_cnt_1_edge3 FIND v(xdut.x2.bit_cnt_1) AT=3.9e-05  $ bit_cnt_1 2us after ADDR+W bit5's SCL rising edge (edge 3 of 8)
.measure tran bit_cnt_2_edge3 FIND v(xdut.x2.bit_cnt_2) AT=3.9e-05  $ bit_cnt_2 2us after ADDR+W bit5's SCL rising edge (edge 3 of 8)
.measure tran lbp_edge3 FIND v(xdut.x2.last_bit_pending) AT=3.9e-05  $ last_bit_pending 2us after ADDR+W bit5's SCL rising edge (edge 3 of 8)
.measure tran bit_cnt_0_edge4 FIND v(xdut.x2.bit_cnt_0) AT=4.9e-05  $ bit_cnt_0 2us after ADDR+W bit4's SCL rising edge (edge 4 of 8)
.measure tran bit_cnt_1_edge4 FIND v(xdut.x2.bit_cnt_1) AT=4.9e-05  $ bit_cnt_1 2us after ADDR+W bit4's SCL rising edge (edge 4 of 8)
.measure tran bit_cnt_2_edge4 FIND v(xdut.x2.bit_cnt_2) AT=4.9e-05  $ bit_cnt_2 2us after ADDR+W bit4's SCL rising edge (edge 4 of 8)
.measure tran lbp_edge4 FIND v(xdut.x2.last_bit_pending) AT=4.9e-05  $ last_bit_pending 2us after ADDR+W bit4's SCL rising edge (edge 4 of 8)
.measure tran bit_cnt_0_edge5 FIND v(xdut.x2.bit_cnt_0) AT=5.9e-05  $ bit_cnt_0 2us after ADDR+W bit3's SCL rising edge (edge 5 of 8)
.measure tran bit_cnt_1_edge5 FIND v(xdut.x2.bit_cnt_1) AT=5.9e-05  $ bit_cnt_1 2us after ADDR+W bit3's SCL rising edge (edge 5 of 8)
.measure tran bit_cnt_2_edge5 FIND v(xdut.x2.bit_cnt_2) AT=5.9e-05  $ bit_cnt_2 2us after ADDR+W bit3's SCL rising edge (edge 5 of 8)
.measure tran lbp_edge5 FIND v(xdut.x2.last_bit_pending) AT=5.9e-05  $ last_bit_pending 2us after ADDR+W bit3's SCL rising edge (edge 5 of 8)
.measure tran bit_cnt_0_edge6 FIND v(xdut.x2.bit_cnt_0) AT=6.9e-05  $ bit_cnt_0 2us after ADDR+W bit2's SCL rising edge (edge 6 of 8)
.measure tran bit_cnt_1_edge6 FIND v(xdut.x2.bit_cnt_1) AT=6.9e-05  $ bit_cnt_1 2us after ADDR+W bit2's SCL rising edge (edge 6 of 8)
.measure tran bit_cnt_2_edge6 FIND v(xdut.x2.bit_cnt_2) AT=6.9e-05  $ bit_cnt_2 2us after ADDR+W bit2's SCL rising edge (edge 6 of 8)
.measure tran lbp_edge6 FIND v(xdut.x2.last_bit_pending) AT=6.9e-05  $ last_bit_pending 2us after ADDR+W bit2's SCL rising edge (edge 6 of 8)
.measure tran bit_cnt_0_edge7 FIND v(xdut.x2.bit_cnt_0) AT=7.9e-05  $ bit_cnt_0 2us after ADDR+W bit1's SCL rising edge (edge 7 of 8)
.measure tran bit_cnt_1_edge7 FIND v(xdut.x2.bit_cnt_1) AT=7.9e-05  $ bit_cnt_1 2us after ADDR+W bit1's SCL rising edge (edge 7 of 8)
.measure tran bit_cnt_2_edge7 FIND v(xdut.x2.bit_cnt_2) AT=7.9e-05  $ bit_cnt_2 2us after ADDR+W bit1's SCL rising edge (edge 7 of 8)
.measure tran lbp_edge7 FIND v(xdut.x2.last_bit_pending) AT=7.9e-05  $ last_bit_pending 2us after ADDR+W bit1's SCL rising edge (edge 7 of 8)
.measure tran bit_cnt_0_edge8 FIND v(xdut.x2.bit_cnt_0) AT=8.9e-05  $ bit_cnt_0 2us after ADDR+W bit0's SCL rising edge (edge 8 of 8)
.measure tran bit_cnt_1_edge8 FIND v(xdut.x2.bit_cnt_1) AT=8.9e-05  $ bit_cnt_1 2us after ADDR+W bit0's SCL rising edge (edge 8 of 8)
.measure tran bit_cnt_2_edge8 FIND v(xdut.x2.bit_cnt_2) AT=8.9e-05  $ bit_cnt_2 2us after ADDR+W bit0's SCL rising edge (edge 8 of 8)
.measure tran lbp_edge8 FIND v(xdut.x2.last_bit_pending) AT=8.9e-05  $ last_bit_pending 2us after ADDR+W bit0's SCL rising edge (edge 8 of 8)

* ---- diagnostic: SDA release slew (pull-up charge time) ----
.measure tran sda_release_trise TRIG v(P2) VAL=1.0 RISE=1 TARG v(P2) VAL=4.5 RISE=1  $ SDA release slew after START, before ADDR+W bit7

.control
  save all
  run

  print rd_bit0 rd_bit1 rd_bit2 rd_bit3 rd_bit4 rd_bit5 rd_bit6 rd_bit7
  print ack0 ack1 ack2 ack3
  print busy_after_start addr_match_write rw_write addr_match_write_x1 addr_match_read rw_read addr_match_read_x1
  print tx_ADDR_W_bit7 tx_ADDR_W_bit6 tx_ADDR_W_bit5 tx_ADDR_W_bit4 tx_ADDR_W_bit3 tx_ADDR_W_bit2 tx_ADDR_W_bit1 tx_ADDR_W_bit0 tx_DATA_write_bit7 tx_DATA_write_bit6 tx_DATA_write_bit5 tx_DATA_write_bit4 tx_DATA_write_bit3 tx_DATA_write_bit2 tx_DATA_write_bit1 tx_DATA_write_bit0 tx_ADDR_R_bit7 tx_ADDR_R_bit6 tx_ADDR_R_bit5 tx_ADDR_R_bit4 tx_ADDR_R_bit3 tx_ADDR_R_bit2 tx_ADDR_R_bit1 tx_ADDR_R_bit0
  print shreg_0_write shreg_1_write shreg_2_write shreg_3_write shreg_4_write shreg_5_write shreg_6_write shreg_0_read shreg_1_read shreg_2_read shreg_3_read shreg_4_read shreg_5_read shreg_6_read
  print phase0_after_start phase1_after_start phase2_after_start bit_cnt_0_at_start_begin bit_cnt_1_at_start_begin bit_cnt_2_at_start_begin lbp_at_start_begin bit_cnt_0_before_bit7_edge bit_cnt_1_before_bit7_edge bit_cnt_2_before_bit7_edge lbp_before_bit7_edge bit_cnt_0_rst_300n phase_0_rst_300n bit_cnt_0_rst_550n phase_0_rst_550n bit_cnt_0_rst_650n phase_0_rst_650n bit_cnt_0_rst_900n phase_0_rst_900n bit_cnt_0_rst_1200n phase_0_rst_1200n bit_cnt_0_rst_1600n phase_0_rst_1600n
  print last_bit_pending_write phase_0_write phase_1_write phase_2_write last_bit_pending_read phase_0_read phase_1_read phase_2_read
  print bit_cnt_0_edge1 bit_cnt_1_edge1 bit_cnt_2_edge1 lbp_edge1 bit_cnt_0_edge2 bit_cnt_1_edge2 bit_cnt_2_edge2 lbp_edge2 bit_cnt_0_edge3 bit_cnt_1_edge3 bit_cnt_2_edge3 lbp_edge3 bit_cnt_0_edge4 bit_cnt_1_edge4 bit_cnt_2_edge4 lbp_edge4 bit_cnt_0_edge5 bit_cnt_1_edge5 bit_cnt_2_edge5 lbp_edge5 bit_cnt_0_edge6 bit_cnt_1_edge6 bit_cnt_2_edge6 lbp_edge6 bit_cnt_0_edge7 bit_cnt_1_edge7 bit_cnt_2_edge7 lbp_edge7 bit_cnt_0_edge8 bit_cnt_1_edge8 bit_cnt_2_edge8 lbp_edge8
  print sda_release_trise

  * rx_data after the write transaction's ACK (expect 0xA5):
  * bit0..7 = ['NC_OUT4', 'NC_OUT12', 'NC_OUT14', 'NC_OUT5', 'NC_OUT6', 'NC_OUT3', 'NC_OUT11', 'NC_OUT13']
  print v(xdut.NC_OUT4) v(xdut.NC_OUT12) v(xdut.NC_OUT14) v(xdut.NC_OUT5) v(xdut.NC_OUT6) v(xdut.NC_OUT3) v(xdut.NC_OUT11) v(xdut.NC_OUT13)

  set filetype=ascii
  write tb_chip_i2c_v10.raw v(P1) v(P2) v(P15) v(xdut.NC_OUT4) v(xdut.NC_OUT12) v(xdut.NC_OUT14) v(xdut.NC_OUT5) v(xdut.NC_OUT6) v(xdut.NC_OUT3) v(xdut.NC_OUT11) v(xdut.NC_OUT13) v(xdut.NC_CORE_busy) v(xdut.NC_CORE_addr_match) v(xdut.NC_CORE_rw) i(vvdd) v(xdut.x2.last_bit_pending) v(xdut.x2.phase_0) v(xdut.x2.phase_1) v(xdut.x2.phase_2) v(xdut.x2.shreg_0) v(xdut.x2.shreg_1) v(xdut.x2.shreg_2) v(xdut.x2.shreg_3) v(xdut.x2.shreg_4) v(xdut.x2.shreg_5) v(xdut.x2.shreg_6) v(xdut.x2.bit_cnt_0) v(xdut.x2.bit_cnt_1) v(xdut.x2.bit_cnt_2)

  * interactive viewing (ignored harmlessly in -b batch mode without a
  * display; run without -b, or `ngspice -b tb_chip_i2c_v10.spice` then
  * load tb_chip_i2c_v10.raw in any viewer, e.g.
  * `ngspice -r tb_chip_i2c_v10.raw` + `plot` at the prompt).
  plot v(P1) v(P2)
  plot v(P15)
  plot v(xdut.NC_OUT4) v(xdut.NC_OUT12) v(xdut.NC_OUT14) v(xdut.NC_OUT5) v(xdut.NC_OUT6) v(xdut.NC_OUT3) v(xdut.NC_OUT11) v(xdut.NC_OUT13)
  plot v(xdut.NC_CORE_busy) v(xdut.NC_CORE_addr_match) v(xdut.NC_CORE_rw)
.endc

.end
