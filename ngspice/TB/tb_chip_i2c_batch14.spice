* tb_chip_i2c_batch14.spice -- auto-generated by script/gen_chip_tb_batch14_v9.py
* DO NOT hand-edit -- regenerate instead.
*
* Minimal 14-check WRITE -> READ -> wrong-address-NACK batch testbench, at
* SCL=100kHz, using the real TR-1um transistor models -- see
* gen_chip_tb_v9.py's own docstring for the full PWL/bus-model rationale
* (unchanged here). This file exists for a clean, routine PASS/FAIL
* regression check (companion: check_batch14.py), matching exactly the
* same 14 checks already used by irsim/irsim_tb.cmd (IRSIM, 14/14 PASS)
* and src/i2c_slave_async_net_tb.v / i2c_slave_async_tb.v (Verilog, 14/14
* PASS both).
*
*   WRITE : S, ADDR+W(0xA0), ACK, DATA=0xA5, ACK, P
*   READ  : S, ADDR+R(0xA1), ACK, DATA=0x3C (slave-driven), NACK, P
*   NEG   : S, ADDR+W(0x22, wrong addr 0x11), expect NACK, P

.include '~/Dropbox/91_OpenPDK/TR-1um/libs.tech/spice/models/ip62_models'
.include '../tr_1um_i2c_slave_async_sim_ready.spice'

.param vdd=5.0

vvdd VDD 0 DC 5.0
vvss VSS 0 DC 0

vrstn P15 0 PWL(0 0 5e-07 0 6e-07 5.0)
vdis P7 0 DC 5.0

rp9 P9 VSS 1G
rp10 P10 VSS 1G

* tx_data (bit0..7 = ['P11', 'P12', 'P13', 'P14', 'P6', 'P5', 'P4', 'P3']), held at 0x3C for the whole run.
vtx0 P11 0 DC 0.0
vtx1 P12 0 DC 0.0
vtx2 P13 0 DC 5.0
vtx3 P14 0 DC 5.0
vtx4 P6 0 DC 5.0
vtx5 P5 0 DC 5.0
vtx6 P4 0 DC 0.0
vtx7 P3 0 DC 0.0

vscl P1 0 PWL(0 5.000 2e-06 5.000 1.19e-05 5.000 1.2e-05 0.000 1.69e-05 0.000 1.7e-05 5.000 2.19e-05 5.000 2.2e-05 0.000 2.69e-05 0.000 2.7e-05 5.000 3.19e-05 5.000 3.2e-05 0.000 3.69e-05 0.000 3.7e-05 5.000 4.19e-05 5.000 4.2e-05 0.000 4.69e-05 0.000 4.7e-05 5.000 5.19e-05 5.000 5.2e-05 0.000 5.69e-05 0.000 5.7e-05 5.000 6.19e-05 5.000 6.2e-05 0.000 6.69e-05 0.000 6.7e-05 5.000 7.19e-05 5.000 7.2e-05 0.000 7.69e-05 0.000 7.7e-05 5.000 8.19e-05 5.000 8.2e-05 0.000 8.69e-05 0.000 8.7e-05 5.000 9.19e-05 5.000 9.2e-05 0.000 9.69e-05 0.000 9.7e-05 5.000 0.0001019 5.000 0.000102 0.000 0.0001069 0.000 0.000107 5.000 0.0001119 5.000 0.000112 0.000 0.0001169 0.000 0.000117 5.000 0.0001219 5.000 0.000122 0.000 0.0001269 0.000 0.000127 5.000 0.0001319 5.000 0.000132 0.000 0.0001369 0.000 0.000137 5.000 0.0001419 5.000 0.000142 0.000 0.0001469 0.000 0.000147 5.000 0.0001519 5.000 0.000152 0.000 0.0001569 0.000 0.000157 5.000 0.0001619 5.000 0.000162 0.000 0.0001669 0.000 0.000167 5.000 0.0001719 5.000 0.000172 0.000 0.0001769 0.000 0.000177 5.000 0.0001819 5.000 0.000182 0.000 0.0001869 0.000 0.000187 5.000 0.0001919 5.000 0.000192 0.000 0.0001969 0.000 0.000197 5.000 0.000207 5.000 0.000212 5.000 0.0002219 5.000 0.000222 0.000 0.0002269 0.000 0.000227 5.000 0.0002319 5.000 0.000232 0.000 0.0002369 0.000 0.000237 5.000 0.0002419 5.000 0.000242 0.000 0.0002469 0.000 0.000247 5.000 0.0002519 5.000 0.000252 0.000 0.0002569 0.000 0.000257 5.000 0.0002619 5.000 0.000262 0.000 0.0002669 0.000 0.000267 5.000 0.0002719 5.000 0.000272 0.000 0.0002769 0.000 0.000277 5.000 0.0002819 5.000 0.000282 0.000 0.0002869 0.000 0.000287 5.000 0.0002919 5.000 0.000292 0.000 0.0002969 0.000 0.000297 5.000 0.0003019 5.000 0.000302 0.000 0.0003069 0.000 0.000307 5.000 0.0003119 5.000 0.000312 0.000 0.0003169 0.000 0.000317 5.000 0.0003219 5.000 0.000322 0.000 0.0003269 0.000 0.000327 5.000 0.0003319 5.000 0.000332 0.000 0.0003369 0.000 0.000337 5.000 0.0003419 5.000 0.000342 0.000 0.0003469 0.000 0.000347 5.000 0.0003519 5.000 0.000352 0.000 0.0003569 0.000 0.000357 5.000 0.0003619 5.000 0.000362 0.000 0.0003669 0.000 0.000367 5.000 0.0003719 5.000 0.000372 0.000 0.0003769 0.000 0.000377 5.000 0.0003819 5.000 0.000382 0.000 0.0003869 0.000 0.000387 5.000 0.0003919 5.000 0.000392 0.000 0.0003969 0.000 0.000397 5.000 0.0004019 5.000 0.000402 0.000 0.0004069 0.000 0.000407 5.000 0.000417 5.000 0.000422 5.000 0.0004319 5.000 0.000432 0.000 0.0004369 0.000 0.000437 5.000 0.0004419 5.000 0.000442 0.000 0.0004469 0.000 0.000447 5.000 0.0004519 5.000 0.000452 0.000 0.0004569 0.000 0.000457 5.000 0.0004619 5.000 0.000462 0.000 0.0004669 0.000 0.000467 5.000 0.0004719 5.000 0.000472 0.000 0.0004769 0.000 0.000477 5.000 0.0004819 5.000 0.000482 0.000 0.0004869 0.000 0.000487 5.000 0.0004919 5.000 0.000492 0.000 0.0004969 0.000 0.000497 5.000 0.0005019 5.000 0.000502 0.000 0.0005069 0.000 0.000507 5.000 0.0005119 5.000 0.000512 0.000 0.0005169 0.000 0.000517 5.000 0.0005219 5.000 0.000522 0.000 0.0005269 0.000 0.000527 5.000 0.000537 5.000 0.000542 5.000)

vsda_ctrl SDA_CTRL 0 PWL(0 0.000 2e-06 0.000 6.9e-06 0.000 7e-06 5.000 1.22e-05 5.000 1.23e-05 0.000 2.22e-05 0.000 2.23e-05 5.000 3.22e-05 5.000 3.23e-05 0.000 4.22e-05 0.000 4.23e-05 5.000 5.23e-05 5.000 6.23e-05 5.000 7.23e-05 5.000 8.23e-05 5.000 9.22e-05 5.000 9.23e-05 0.000 0.0001023 0.000 0.0001122 0.000 0.0001123 5.000 0.0001222 5.000 0.0001223 0.000 0.0001322 0.000 0.0001323 5.000 0.0001423 5.000 0.0001522 5.000 0.0001523 0.000 0.0001622 0.000 0.0001623 5.000 0.0001722 5.000 0.0001723 0.000 0.0001823 0.000 0.0001922 0.000 0.0001923 5.000 0.0002019 5.000 0.000202 0.000 0.000207 0.000 0.000212 0.000 0.0002169 0.000 0.000217 5.000 0.0002222 5.000 0.0002223 0.000 0.0002322 0.000 0.0002323 5.000 0.0002422 5.000 0.0002423 0.000 0.0002522 0.000 0.0002523 5.000 0.0002623 5.000 0.0002723 5.000 0.0002823 5.000 0.0002922 5.000 0.0002923 0.000 0.0003023 0.000 0.0003123 0.000 0.0003223 0.000 0.0003323 0.000 0.0003423 0.000 0.0003523 0.000 0.0003623 0.000 0.0003723 0.000 0.0003823 0.000 0.0003923 0.000 0.0004022 0.000 0.0004023 5.000 0.0004119 5.000 0.000412 0.000 0.000417 0.000 0.000422 0.000 0.0004269 0.000 0.000427 5.000 0.0004323 5.000 0.0004423 5.000 0.0004522 5.000 0.0004523 0.000 0.0004622 0.000 0.0004623 5.000 0.0004723 5.000 0.0004823 5.000 0.0004922 5.000 0.0004923 0.000 0.0005022 0.000 0.0005023 5.000 0.0005122 5.000 0.0005123 0.000 0.0005222 0.000 0.0005223 5.000 0.0005319 5.000 0.000532 0.000 0.000537 0.000 0.000542 0.000)
.model SDASW SW(RON=10 ROFF=1MEG VT=2.5 VH=0.3)
ssda P2 0 SDA_CTRL 0 SDASW
rpu P2 VDD 10k

xdut P1 P2 P3 P4 P5 P6 P7 VSS P9 P10 P11 P12 P13 P14 P15 VDD tr_1um_i2c_slave_async

.tran 50n 0.000544

* ---- the 14 checks ----
.measure tran busy_after_start FIND v(xdut.NC_CORE_busy) AT=9.5e-06  $ expect ~VDD -- busy asserted after START
.measure tran ack_addr_write FIND v(P2) AT=9.95e-05  $ expect ~0V -- slave ACKed matching address (write)
.measure tran addr_match_write FIND v(xdut.NC_CORE_addr_match) AT=0.0001018  $ expect ~VDD -- addr_match asserted
.measure tran rw_write FIND v(xdut.NC_CORE_rw) AT=0.0001018  $ expect ~0V -- rw indicates WRITE
.measure tran ack_data FIND v(P2) AT=0.0001895  $ expect ~0V -- slave ACKed data byte
.measure tran rx_data_bit0 FIND v(xdut.NC_OUT11) AT=0.000194  $ rx_data == 0xA5 -- bit0
.measure tran rx_data_bit1 FIND v(xdut.NC_OUT12) AT=0.000194  $ rx_data == 0xA5 -- bit1
.measure tran rx_data_bit2 FIND v(xdut.NC_OUT13) AT=0.000194  $ rx_data == 0xA5 -- bit2
.measure tran rx_data_bit3 FIND v(xdut.NC_OUT14) AT=0.000194  $ rx_data == 0xA5 -- bit3
.measure tran rx_data_bit4 FIND v(xdut.NC_OUT6) AT=0.000194  $ rx_data == 0xA5 -- bit4
.measure tran rx_data_bit5 FIND v(xdut.NC_OUT5) AT=0.000194  $ rx_data == 0xA5 -- bit5
.measure tran rx_data_bit6 FIND v(xdut.NC_OUT4) AT=0.000194  $ rx_data == 0xA5 -- bit6
.measure tran rx_data_bit7 FIND v(xdut.NC_OUT3) AT=0.000194  $ rx_data == 0xA5 -- bit7
.measure tran busy_after_stop1 FIND v(xdut.NC_CORE_busy) AT=0.000209  $ expect ~0V -- busy cleared after STOP
.measure tran ack_addr_read FIND v(P2) AT=0.0003095  $ expect ~0V -- slave ACKed matching address (read)
.measure tran rw_read FIND v(xdut.NC_CORE_rw) AT=0.0003118  $ expect ~VDD -- rw indicates READ
.measure tran read_byte_bit0 FIND v(P2) AT=0.0003195  $ read byte == 0x3C -- bit0
.measure tran read_byte_bit1 FIND v(P2) AT=0.0003295  $ read byte == 0x3C -- bit1
.measure tran read_byte_bit2 FIND v(P2) AT=0.0003395  $ read byte == 0x3C -- bit2
.measure tran read_byte_bit3 FIND v(P2) AT=0.0003495  $ read byte == 0x3C -- bit3
.measure tran read_byte_bit4 FIND v(P2) AT=0.0003595  $ read byte == 0x3C -- bit4
.measure tran read_byte_bit5 FIND v(P2) AT=0.0003695  $ read byte == 0x3C -- bit5
.measure tran read_byte_bit6 FIND v(P2) AT=0.0003795  $ read byte == 0x3C -- bit6
.measure tran read_byte_bit7 FIND v(P2) AT=0.0003895  $ read byte == 0x3C -- bit7
.measure tran busy_after_stop2 FIND v(xdut.NC_CORE_busy) AT=0.000419  $ expect ~0V -- busy cleared after final STOP
.measure tran nack_wrong_addr FIND v(P2) AT=0.0005195  $ expect ~VDD -- unmatched address -> NACK (no slave ack)
.measure tran addr_match_wrong FIND v(xdut.NC_CORE_addr_match) AT=0.0005218  $ expect ~0V -- addr_match not asserted for foreign address
.measure tran busy_after_stop3 FIND v(xdut.NC_CORE_busy) AT=0.000539  $ expect ~0V -- busy cleared after STOP following NACK

* ---- diagnostic-only: STOP1 detector-chain trace (see gen_chip_tb_
* batch14_v9.py's own comment) -- not part of the 14-item pass/fail list,
* only emitted to localize a busy_after_stop1 FAIL if one occurs.
.measure tran rxe_i7_pre50n_sel_087 FIND v(xdut.x2._087_) AT=0.00010695  $ sel_087 at DATA-byte bit_index=7 (DATA (write)) edgepre50n
.measure tran rxe_i7_pre50n_last_bit_pending FIND v(xdut.x2.last_bit_pending) AT=0.00010695  $ last_bit_pending at DATA-byte bit_index=7 (DATA (write)) edgepre50n
.measure tran rxe_i7_pre50n_shreg_0 FIND v(xdut.x2.shreg_0) AT=0.00010695  $ shreg_0 at DATA-byte bit_index=7 (DATA (write)) edgepre50n
.measure tran rxe_i7_pre50n_shreg_1 FIND v(xdut.x2.shreg_1) AT=0.00010695  $ shreg_1 at DATA-byte bit_index=7 (DATA (write)) edgepre50n
.measure tran rxe_i7_pre50n_shreg_2 FIND v(xdut.x2.shreg_2) AT=0.00010695  $ shreg_2 at DATA-byte bit_index=7 (DATA (write)) edgepre50n
.measure tran rxe_i7_pre50n_shreg_3 FIND v(xdut.x2.shreg_3) AT=0.00010695  $ shreg_3 at DATA-byte bit_index=7 (DATA (write)) edgepre50n
.measure tran rxe_i7_pre50n_shreg_4 FIND v(xdut.x2.shreg_4) AT=0.00010695  $ shreg_4 at DATA-byte bit_index=7 (DATA (write)) edgepre50n
.measure tran rxe_i7_pre50n_shreg_5 FIND v(xdut.x2.shreg_5) AT=0.00010695  $ shreg_5 at DATA-byte bit_index=7 (DATA (write)) edgepre50n
.measure tran rxe_i7_pre50n_shreg_6 FIND v(xdut.x2.shreg_6) AT=0.00010695  $ shreg_6 at DATA-byte bit_index=7 (DATA (write)) edgepre50n
.measure tran rxe_i7_pre50n_sda_in_row2 FIND v(xdut.x2.sda_in_row2) AT=0.00010695  $ sda_in_row2 at DATA-byte bit_index=7 (DATA (write)) edgepre50n
.measure tran rxe_i7_pre50n_scl_row2 FIND v(xdut.x2.scl_row2) AT=0.00010695  $ scl_row2 at DATA-byte bit_index=7 (DATA (write)) edgepre50n
.measure tran rxe_i7_post50n_sel_087 FIND v(xdut.x2._087_) AT=0.00010705  $ sel_087 at DATA-byte bit_index=7 (DATA (write)) edgepost50n
.measure tran rxe_i7_post50n_last_bit_pending FIND v(xdut.x2.last_bit_pending) AT=0.00010705  $ last_bit_pending at DATA-byte bit_index=7 (DATA (write)) edgepost50n
.measure tran rxe_i7_post50n_shreg_0 FIND v(xdut.x2.shreg_0) AT=0.00010705  $ shreg_0 at DATA-byte bit_index=7 (DATA (write)) edgepost50n
.measure tran rxe_i7_post50n_shreg_1 FIND v(xdut.x2.shreg_1) AT=0.00010705  $ shreg_1 at DATA-byte bit_index=7 (DATA (write)) edgepost50n
.measure tran rxe_i7_post50n_shreg_2 FIND v(xdut.x2.shreg_2) AT=0.00010705  $ shreg_2 at DATA-byte bit_index=7 (DATA (write)) edgepost50n
.measure tran rxe_i7_post50n_shreg_3 FIND v(xdut.x2.shreg_3) AT=0.00010705  $ shreg_3 at DATA-byte bit_index=7 (DATA (write)) edgepost50n
.measure tran rxe_i7_post50n_shreg_4 FIND v(xdut.x2.shreg_4) AT=0.00010705  $ shreg_4 at DATA-byte bit_index=7 (DATA (write)) edgepost50n
.measure tran rxe_i7_post50n_shreg_5 FIND v(xdut.x2.shreg_5) AT=0.00010705  $ shreg_5 at DATA-byte bit_index=7 (DATA (write)) edgepost50n
.measure tran rxe_i7_post50n_shreg_6 FIND v(xdut.x2.shreg_6) AT=0.00010705  $ shreg_6 at DATA-byte bit_index=7 (DATA (write)) edgepost50n
.measure tran rxe_i7_post50n_sda_in_row2 FIND v(xdut.x2.sda_in_row2) AT=0.00010705  $ sda_in_row2 at DATA-byte bit_index=7 (DATA (write)) edgepost50n
.measure tran rxe_i7_post50n_scl_row2 FIND v(xdut.x2.scl_row2) AT=0.00010705  $ scl_row2 at DATA-byte bit_index=7 (DATA (write)) edgepost50n
.measure tran rxe_i7_post500n_sel_087 FIND v(xdut.x2._087_) AT=0.0001075  $ sel_087 at DATA-byte bit_index=7 (DATA (write)) edgepost500n
.measure tran rxe_i7_post500n_last_bit_pending FIND v(xdut.x2.last_bit_pending) AT=0.0001075  $ last_bit_pending at DATA-byte bit_index=7 (DATA (write)) edgepost500n
.measure tran rxe_i7_post500n_shreg_0 FIND v(xdut.x2.shreg_0) AT=0.0001075  $ shreg_0 at DATA-byte bit_index=7 (DATA (write)) edgepost500n
.measure tran rxe_i7_post500n_shreg_1 FIND v(xdut.x2.shreg_1) AT=0.0001075  $ shreg_1 at DATA-byte bit_index=7 (DATA (write)) edgepost500n
.measure tran rxe_i7_post500n_shreg_2 FIND v(xdut.x2.shreg_2) AT=0.0001075  $ shreg_2 at DATA-byte bit_index=7 (DATA (write)) edgepost500n
.measure tran rxe_i7_post500n_shreg_3 FIND v(xdut.x2.shreg_3) AT=0.0001075  $ shreg_3 at DATA-byte bit_index=7 (DATA (write)) edgepost500n
.measure tran rxe_i7_post500n_shreg_4 FIND v(xdut.x2.shreg_4) AT=0.0001075  $ shreg_4 at DATA-byte bit_index=7 (DATA (write)) edgepost500n
.measure tran rxe_i7_post500n_shreg_5 FIND v(xdut.x2.shreg_5) AT=0.0001075  $ shreg_5 at DATA-byte bit_index=7 (DATA (write)) edgepost500n
.measure tran rxe_i7_post500n_shreg_6 FIND v(xdut.x2.shreg_6) AT=0.0001075  $ shreg_6 at DATA-byte bit_index=7 (DATA (write)) edgepost500n
.measure tran rxe_i7_post500n_sda_in_row2 FIND v(xdut.x2.sda_in_row2) AT=0.0001075  $ sda_in_row2 at DATA-byte bit_index=7 (DATA (write)) edgepost500n
.measure tran rxe_i7_post500n_scl_row2 FIND v(xdut.x2.scl_row2) AT=0.0001075  $ scl_row2 at DATA-byte bit_index=7 (DATA (write)) edgepost500n
.measure tran rxe_i6_pre50n_sel_087 FIND v(xdut.x2._087_) AT=0.00011695  $ sel_087 at DATA-byte bit_index=6 (DATA (write)) edgepre50n
.measure tran rxe_i6_pre50n_last_bit_pending FIND v(xdut.x2.last_bit_pending) AT=0.00011695  $ last_bit_pending at DATA-byte bit_index=6 (DATA (write)) edgepre50n
.measure tran rxe_i6_pre50n_shreg_0 FIND v(xdut.x2.shreg_0) AT=0.00011695  $ shreg_0 at DATA-byte bit_index=6 (DATA (write)) edgepre50n
.measure tran rxe_i6_pre50n_shreg_1 FIND v(xdut.x2.shreg_1) AT=0.00011695  $ shreg_1 at DATA-byte bit_index=6 (DATA (write)) edgepre50n
.measure tran rxe_i6_pre50n_shreg_2 FIND v(xdut.x2.shreg_2) AT=0.00011695  $ shreg_2 at DATA-byte bit_index=6 (DATA (write)) edgepre50n
.measure tran rxe_i6_pre50n_shreg_3 FIND v(xdut.x2.shreg_3) AT=0.00011695  $ shreg_3 at DATA-byte bit_index=6 (DATA (write)) edgepre50n
.measure tran rxe_i6_pre50n_shreg_4 FIND v(xdut.x2.shreg_4) AT=0.00011695  $ shreg_4 at DATA-byte bit_index=6 (DATA (write)) edgepre50n
.measure tran rxe_i6_pre50n_shreg_5 FIND v(xdut.x2.shreg_5) AT=0.00011695  $ shreg_5 at DATA-byte bit_index=6 (DATA (write)) edgepre50n
.measure tran rxe_i6_pre50n_shreg_6 FIND v(xdut.x2.shreg_6) AT=0.00011695  $ shreg_6 at DATA-byte bit_index=6 (DATA (write)) edgepre50n
.measure tran rxe_i6_pre50n_sda_in_row2 FIND v(xdut.x2.sda_in_row2) AT=0.00011695  $ sda_in_row2 at DATA-byte bit_index=6 (DATA (write)) edgepre50n
.measure tran rxe_i6_pre50n_scl_row2 FIND v(xdut.x2.scl_row2) AT=0.00011695  $ scl_row2 at DATA-byte bit_index=6 (DATA (write)) edgepre50n
.measure tran rxe_i6_post50n_sel_087 FIND v(xdut.x2._087_) AT=0.00011705  $ sel_087 at DATA-byte bit_index=6 (DATA (write)) edgepost50n
.measure tran rxe_i6_post50n_last_bit_pending FIND v(xdut.x2.last_bit_pending) AT=0.00011705  $ last_bit_pending at DATA-byte bit_index=6 (DATA (write)) edgepost50n
.measure tran rxe_i6_post50n_shreg_0 FIND v(xdut.x2.shreg_0) AT=0.00011705  $ shreg_0 at DATA-byte bit_index=6 (DATA (write)) edgepost50n
.measure tran rxe_i6_post50n_shreg_1 FIND v(xdut.x2.shreg_1) AT=0.00011705  $ shreg_1 at DATA-byte bit_index=6 (DATA (write)) edgepost50n
.measure tran rxe_i6_post50n_shreg_2 FIND v(xdut.x2.shreg_2) AT=0.00011705  $ shreg_2 at DATA-byte bit_index=6 (DATA (write)) edgepost50n
.measure tran rxe_i6_post50n_shreg_3 FIND v(xdut.x2.shreg_3) AT=0.00011705  $ shreg_3 at DATA-byte bit_index=6 (DATA (write)) edgepost50n
.measure tran rxe_i6_post50n_shreg_4 FIND v(xdut.x2.shreg_4) AT=0.00011705  $ shreg_4 at DATA-byte bit_index=6 (DATA (write)) edgepost50n
.measure tran rxe_i6_post50n_shreg_5 FIND v(xdut.x2.shreg_5) AT=0.00011705  $ shreg_5 at DATA-byte bit_index=6 (DATA (write)) edgepost50n
.measure tran rxe_i6_post50n_shreg_6 FIND v(xdut.x2.shreg_6) AT=0.00011705  $ shreg_6 at DATA-byte bit_index=6 (DATA (write)) edgepost50n
.measure tran rxe_i6_post50n_sda_in_row2 FIND v(xdut.x2.sda_in_row2) AT=0.00011705  $ sda_in_row2 at DATA-byte bit_index=6 (DATA (write)) edgepost50n
.measure tran rxe_i6_post50n_scl_row2 FIND v(xdut.x2.scl_row2) AT=0.00011705  $ scl_row2 at DATA-byte bit_index=6 (DATA (write)) edgepost50n
.measure tran rxe_i6_post500n_sel_087 FIND v(xdut.x2._087_) AT=0.0001175  $ sel_087 at DATA-byte bit_index=6 (DATA (write)) edgepost500n
.measure tran rxe_i6_post500n_last_bit_pending FIND v(xdut.x2.last_bit_pending) AT=0.0001175  $ last_bit_pending at DATA-byte bit_index=6 (DATA (write)) edgepost500n
.measure tran rxe_i6_post500n_shreg_0 FIND v(xdut.x2.shreg_0) AT=0.0001175  $ shreg_0 at DATA-byte bit_index=6 (DATA (write)) edgepost500n
.measure tran rxe_i6_post500n_shreg_1 FIND v(xdut.x2.shreg_1) AT=0.0001175  $ shreg_1 at DATA-byte bit_index=6 (DATA (write)) edgepost500n
.measure tran rxe_i6_post500n_shreg_2 FIND v(xdut.x2.shreg_2) AT=0.0001175  $ shreg_2 at DATA-byte bit_index=6 (DATA (write)) edgepost500n
.measure tran rxe_i6_post500n_shreg_3 FIND v(xdut.x2.shreg_3) AT=0.0001175  $ shreg_3 at DATA-byte bit_index=6 (DATA (write)) edgepost500n
.measure tran rxe_i6_post500n_shreg_4 FIND v(xdut.x2.shreg_4) AT=0.0001175  $ shreg_4 at DATA-byte bit_index=6 (DATA (write)) edgepost500n
.measure tran rxe_i6_post500n_shreg_5 FIND v(xdut.x2.shreg_5) AT=0.0001175  $ shreg_5 at DATA-byte bit_index=6 (DATA (write)) edgepost500n
.measure tran rxe_i6_post500n_shreg_6 FIND v(xdut.x2.shreg_6) AT=0.0001175  $ shreg_6 at DATA-byte bit_index=6 (DATA (write)) edgepost500n
.measure tran rxe_i6_post500n_sda_in_row2 FIND v(xdut.x2.sda_in_row2) AT=0.0001175  $ sda_in_row2 at DATA-byte bit_index=6 (DATA (write)) edgepost500n
.measure tran rxe_i6_post500n_scl_row2 FIND v(xdut.x2.scl_row2) AT=0.0001175  $ scl_row2 at DATA-byte bit_index=6 (DATA (write)) edgepost500n
.measure tran rxe_i5_pre50n_sel_087 FIND v(xdut.x2._087_) AT=0.00012695  $ sel_087 at DATA-byte bit_index=5 (DATA (write)) edgepre50n
.measure tran rxe_i5_pre50n_last_bit_pending FIND v(xdut.x2.last_bit_pending) AT=0.00012695  $ last_bit_pending at DATA-byte bit_index=5 (DATA (write)) edgepre50n
.measure tran rxe_i5_pre50n_shreg_0 FIND v(xdut.x2.shreg_0) AT=0.00012695  $ shreg_0 at DATA-byte bit_index=5 (DATA (write)) edgepre50n
.measure tran rxe_i5_pre50n_shreg_1 FIND v(xdut.x2.shreg_1) AT=0.00012695  $ shreg_1 at DATA-byte bit_index=5 (DATA (write)) edgepre50n
.measure tran rxe_i5_pre50n_shreg_2 FIND v(xdut.x2.shreg_2) AT=0.00012695  $ shreg_2 at DATA-byte bit_index=5 (DATA (write)) edgepre50n
.measure tran rxe_i5_pre50n_shreg_3 FIND v(xdut.x2.shreg_3) AT=0.00012695  $ shreg_3 at DATA-byte bit_index=5 (DATA (write)) edgepre50n
.measure tran rxe_i5_pre50n_shreg_4 FIND v(xdut.x2.shreg_4) AT=0.00012695  $ shreg_4 at DATA-byte bit_index=5 (DATA (write)) edgepre50n
.measure tran rxe_i5_pre50n_shreg_5 FIND v(xdut.x2.shreg_5) AT=0.00012695  $ shreg_5 at DATA-byte bit_index=5 (DATA (write)) edgepre50n
.measure tran rxe_i5_pre50n_shreg_6 FIND v(xdut.x2.shreg_6) AT=0.00012695  $ shreg_6 at DATA-byte bit_index=5 (DATA (write)) edgepre50n
.measure tran rxe_i5_pre50n_sda_in_row2 FIND v(xdut.x2.sda_in_row2) AT=0.00012695  $ sda_in_row2 at DATA-byte bit_index=5 (DATA (write)) edgepre50n
.measure tran rxe_i5_pre50n_scl_row2 FIND v(xdut.x2.scl_row2) AT=0.00012695  $ scl_row2 at DATA-byte bit_index=5 (DATA (write)) edgepre50n
.measure tran rxe_i5_post50n_sel_087 FIND v(xdut.x2._087_) AT=0.00012705  $ sel_087 at DATA-byte bit_index=5 (DATA (write)) edgepost50n
.measure tran rxe_i5_post50n_last_bit_pending FIND v(xdut.x2.last_bit_pending) AT=0.00012705  $ last_bit_pending at DATA-byte bit_index=5 (DATA (write)) edgepost50n
.measure tran rxe_i5_post50n_shreg_0 FIND v(xdut.x2.shreg_0) AT=0.00012705  $ shreg_0 at DATA-byte bit_index=5 (DATA (write)) edgepost50n
.measure tran rxe_i5_post50n_shreg_1 FIND v(xdut.x2.shreg_1) AT=0.00012705  $ shreg_1 at DATA-byte bit_index=5 (DATA (write)) edgepost50n
.measure tran rxe_i5_post50n_shreg_2 FIND v(xdut.x2.shreg_2) AT=0.00012705  $ shreg_2 at DATA-byte bit_index=5 (DATA (write)) edgepost50n
.measure tran rxe_i5_post50n_shreg_3 FIND v(xdut.x2.shreg_3) AT=0.00012705  $ shreg_3 at DATA-byte bit_index=5 (DATA (write)) edgepost50n
.measure tran rxe_i5_post50n_shreg_4 FIND v(xdut.x2.shreg_4) AT=0.00012705  $ shreg_4 at DATA-byte bit_index=5 (DATA (write)) edgepost50n
.measure tran rxe_i5_post50n_shreg_5 FIND v(xdut.x2.shreg_5) AT=0.00012705  $ shreg_5 at DATA-byte bit_index=5 (DATA (write)) edgepost50n
.measure tran rxe_i5_post50n_shreg_6 FIND v(xdut.x2.shreg_6) AT=0.00012705  $ shreg_6 at DATA-byte bit_index=5 (DATA (write)) edgepost50n
.measure tran rxe_i5_post50n_sda_in_row2 FIND v(xdut.x2.sda_in_row2) AT=0.00012705  $ sda_in_row2 at DATA-byte bit_index=5 (DATA (write)) edgepost50n
.measure tran rxe_i5_post50n_scl_row2 FIND v(xdut.x2.scl_row2) AT=0.00012705  $ scl_row2 at DATA-byte bit_index=5 (DATA (write)) edgepost50n
.measure tran rxe_i5_post500n_sel_087 FIND v(xdut.x2._087_) AT=0.0001275  $ sel_087 at DATA-byte bit_index=5 (DATA (write)) edgepost500n
.measure tran rxe_i5_post500n_last_bit_pending FIND v(xdut.x2.last_bit_pending) AT=0.0001275  $ last_bit_pending at DATA-byte bit_index=5 (DATA (write)) edgepost500n
.measure tran rxe_i5_post500n_shreg_0 FIND v(xdut.x2.shreg_0) AT=0.0001275  $ shreg_0 at DATA-byte bit_index=5 (DATA (write)) edgepost500n
.measure tran rxe_i5_post500n_shreg_1 FIND v(xdut.x2.shreg_1) AT=0.0001275  $ shreg_1 at DATA-byte bit_index=5 (DATA (write)) edgepost500n
.measure tran rxe_i5_post500n_shreg_2 FIND v(xdut.x2.shreg_2) AT=0.0001275  $ shreg_2 at DATA-byte bit_index=5 (DATA (write)) edgepost500n
.measure tran rxe_i5_post500n_shreg_3 FIND v(xdut.x2.shreg_3) AT=0.0001275  $ shreg_3 at DATA-byte bit_index=5 (DATA (write)) edgepost500n
.measure tran rxe_i5_post500n_shreg_4 FIND v(xdut.x2.shreg_4) AT=0.0001275  $ shreg_4 at DATA-byte bit_index=5 (DATA (write)) edgepost500n
.measure tran rxe_i5_post500n_shreg_5 FIND v(xdut.x2.shreg_5) AT=0.0001275  $ shreg_5 at DATA-byte bit_index=5 (DATA (write)) edgepost500n
.measure tran rxe_i5_post500n_shreg_6 FIND v(xdut.x2.shreg_6) AT=0.0001275  $ shreg_6 at DATA-byte bit_index=5 (DATA (write)) edgepost500n
.measure tran rxe_i5_post500n_sda_in_row2 FIND v(xdut.x2.sda_in_row2) AT=0.0001275  $ sda_in_row2 at DATA-byte bit_index=5 (DATA (write)) edgepost500n
.measure tran rxe_i5_post500n_scl_row2 FIND v(xdut.x2.scl_row2) AT=0.0001275  $ scl_row2 at DATA-byte bit_index=5 (DATA (write)) edgepost500n
.measure tran rxe_i4_pre50n_sel_087 FIND v(xdut.x2._087_) AT=0.00013695  $ sel_087 at DATA-byte bit_index=4 (DATA (write)) edgepre50n
.measure tran rxe_i4_pre50n_last_bit_pending FIND v(xdut.x2.last_bit_pending) AT=0.00013695  $ last_bit_pending at DATA-byte bit_index=4 (DATA (write)) edgepre50n
.measure tran rxe_i4_pre50n_shreg_0 FIND v(xdut.x2.shreg_0) AT=0.00013695  $ shreg_0 at DATA-byte bit_index=4 (DATA (write)) edgepre50n
.measure tran rxe_i4_pre50n_shreg_1 FIND v(xdut.x2.shreg_1) AT=0.00013695  $ shreg_1 at DATA-byte bit_index=4 (DATA (write)) edgepre50n
.measure tran rxe_i4_pre50n_shreg_2 FIND v(xdut.x2.shreg_2) AT=0.00013695  $ shreg_2 at DATA-byte bit_index=4 (DATA (write)) edgepre50n
.measure tran rxe_i4_pre50n_shreg_3 FIND v(xdut.x2.shreg_3) AT=0.00013695  $ shreg_3 at DATA-byte bit_index=4 (DATA (write)) edgepre50n
.measure tran rxe_i4_pre50n_shreg_4 FIND v(xdut.x2.shreg_4) AT=0.00013695  $ shreg_4 at DATA-byte bit_index=4 (DATA (write)) edgepre50n
.measure tran rxe_i4_pre50n_shreg_5 FIND v(xdut.x2.shreg_5) AT=0.00013695  $ shreg_5 at DATA-byte bit_index=4 (DATA (write)) edgepre50n
.measure tran rxe_i4_pre50n_shreg_6 FIND v(xdut.x2.shreg_6) AT=0.00013695  $ shreg_6 at DATA-byte bit_index=4 (DATA (write)) edgepre50n
.measure tran rxe_i4_pre50n_sda_in_row2 FIND v(xdut.x2.sda_in_row2) AT=0.00013695  $ sda_in_row2 at DATA-byte bit_index=4 (DATA (write)) edgepre50n
.measure tran rxe_i4_pre50n_scl_row2 FIND v(xdut.x2.scl_row2) AT=0.00013695  $ scl_row2 at DATA-byte bit_index=4 (DATA (write)) edgepre50n
.measure tran rxe_i4_post50n_sel_087 FIND v(xdut.x2._087_) AT=0.00013705  $ sel_087 at DATA-byte bit_index=4 (DATA (write)) edgepost50n
.measure tran rxe_i4_post50n_last_bit_pending FIND v(xdut.x2.last_bit_pending) AT=0.00013705  $ last_bit_pending at DATA-byte bit_index=4 (DATA (write)) edgepost50n
.measure tran rxe_i4_post50n_shreg_0 FIND v(xdut.x2.shreg_0) AT=0.00013705  $ shreg_0 at DATA-byte bit_index=4 (DATA (write)) edgepost50n
.measure tran rxe_i4_post50n_shreg_1 FIND v(xdut.x2.shreg_1) AT=0.00013705  $ shreg_1 at DATA-byte bit_index=4 (DATA (write)) edgepost50n
.measure tran rxe_i4_post50n_shreg_2 FIND v(xdut.x2.shreg_2) AT=0.00013705  $ shreg_2 at DATA-byte bit_index=4 (DATA (write)) edgepost50n
.measure tran rxe_i4_post50n_shreg_3 FIND v(xdut.x2.shreg_3) AT=0.00013705  $ shreg_3 at DATA-byte bit_index=4 (DATA (write)) edgepost50n
.measure tran rxe_i4_post50n_shreg_4 FIND v(xdut.x2.shreg_4) AT=0.00013705  $ shreg_4 at DATA-byte bit_index=4 (DATA (write)) edgepost50n
.measure tran rxe_i4_post50n_shreg_5 FIND v(xdut.x2.shreg_5) AT=0.00013705  $ shreg_5 at DATA-byte bit_index=4 (DATA (write)) edgepost50n
.measure tran rxe_i4_post50n_shreg_6 FIND v(xdut.x2.shreg_6) AT=0.00013705  $ shreg_6 at DATA-byte bit_index=4 (DATA (write)) edgepost50n
.measure tran rxe_i4_post50n_sda_in_row2 FIND v(xdut.x2.sda_in_row2) AT=0.00013705  $ sda_in_row2 at DATA-byte bit_index=4 (DATA (write)) edgepost50n
.measure tran rxe_i4_post50n_scl_row2 FIND v(xdut.x2.scl_row2) AT=0.00013705  $ scl_row2 at DATA-byte bit_index=4 (DATA (write)) edgepost50n
.measure tran rxe_i4_post500n_sel_087 FIND v(xdut.x2._087_) AT=0.0001375  $ sel_087 at DATA-byte bit_index=4 (DATA (write)) edgepost500n
.measure tran rxe_i4_post500n_last_bit_pending FIND v(xdut.x2.last_bit_pending) AT=0.0001375  $ last_bit_pending at DATA-byte bit_index=4 (DATA (write)) edgepost500n
.measure tran rxe_i4_post500n_shreg_0 FIND v(xdut.x2.shreg_0) AT=0.0001375  $ shreg_0 at DATA-byte bit_index=4 (DATA (write)) edgepost500n
.measure tran rxe_i4_post500n_shreg_1 FIND v(xdut.x2.shreg_1) AT=0.0001375  $ shreg_1 at DATA-byte bit_index=4 (DATA (write)) edgepost500n
.measure tran rxe_i4_post500n_shreg_2 FIND v(xdut.x2.shreg_2) AT=0.0001375  $ shreg_2 at DATA-byte bit_index=4 (DATA (write)) edgepost500n
.measure tran rxe_i4_post500n_shreg_3 FIND v(xdut.x2.shreg_3) AT=0.0001375  $ shreg_3 at DATA-byte bit_index=4 (DATA (write)) edgepost500n
.measure tran rxe_i4_post500n_shreg_4 FIND v(xdut.x2.shreg_4) AT=0.0001375  $ shreg_4 at DATA-byte bit_index=4 (DATA (write)) edgepost500n
.measure tran rxe_i4_post500n_shreg_5 FIND v(xdut.x2.shreg_5) AT=0.0001375  $ shreg_5 at DATA-byte bit_index=4 (DATA (write)) edgepost500n
.measure tran rxe_i4_post500n_shreg_6 FIND v(xdut.x2.shreg_6) AT=0.0001375  $ shreg_6 at DATA-byte bit_index=4 (DATA (write)) edgepost500n
.measure tran rxe_i4_post500n_sda_in_row2 FIND v(xdut.x2.sda_in_row2) AT=0.0001375  $ sda_in_row2 at DATA-byte bit_index=4 (DATA (write)) edgepost500n
.measure tran rxe_i4_post500n_scl_row2 FIND v(xdut.x2.scl_row2) AT=0.0001375  $ scl_row2 at DATA-byte bit_index=4 (DATA (write)) edgepost500n
.measure tran rxe_i3_pre50n_sel_087 FIND v(xdut.x2._087_) AT=0.00014695  $ sel_087 at DATA-byte bit_index=3 (DATA (write)) edgepre50n
.measure tran rxe_i3_pre50n_last_bit_pending FIND v(xdut.x2.last_bit_pending) AT=0.00014695  $ last_bit_pending at DATA-byte bit_index=3 (DATA (write)) edgepre50n
.measure tran rxe_i3_pre50n_shreg_0 FIND v(xdut.x2.shreg_0) AT=0.00014695  $ shreg_0 at DATA-byte bit_index=3 (DATA (write)) edgepre50n
.measure tran rxe_i3_pre50n_shreg_1 FIND v(xdut.x2.shreg_1) AT=0.00014695  $ shreg_1 at DATA-byte bit_index=3 (DATA (write)) edgepre50n
.measure tran rxe_i3_pre50n_shreg_2 FIND v(xdut.x2.shreg_2) AT=0.00014695  $ shreg_2 at DATA-byte bit_index=3 (DATA (write)) edgepre50n
.measure tran rxe_i3_pre50n_shreg_3 FIND v(xdut.x2.shreg_3) AT=0.00014695  $ shreg_3 at DATA-byte bit_index=3 (DATA (write)) edgepre50n
.measure tran rxe_i3_pre50n_shreg_4 FIND v(xdut.x2.shreg_4) AT=0.00014695  $ shreg_4 at DATA-byte bit_index=3 (DATA (write)) edgepre50n
.measure tran rxe_i3_pre50n_shreg_5 FIND v(xdut.x2.shreg_5) AT=0.00014695  $ shreg_5 at DATA-byte bit_index=3 (DATA (write)) edgepre50n
.measure tran rxe_i3_pre50n_shreg_6 FIND v(xdut.x2.shreg_6) AT=0.00014695  $ shreg_6 at DATA-byte bit_index=3 (DATA (write)) edgepre50n
.measure tran rxe_i3_pre50n_sda_in_row2 FIND v(xdut.x2.sda_in_row2) AT=0.00014695  $ sda_in_row2 at DATA-byte bit_index=3 (DATA (write)) edgepre50n
.measure tran rxe_i3_pre50n_scl_row2 FIND v(xdut.x2.scl_row2) AT=0.00014695  $ scl_row2 at DATA-byte bit_index=3 (DATA (write)) edgepre50n
.measure tran rxe_i3_post50n_sel_087 FIND v(xdut.x2._087_) AT=0.00014705  $ sel_087 at DATA-byte bit_index=3 (DATA (write)) edgepost50n
.measure tran rxe_i3_post50n_last_bit_pending FIND v(xdut.x2.last_bit_pending) AT=0.00014705  $ last_bit_pending at DATA-byte bit_index=3 (DATA (write)) edgepost50n
.measure tran rxe_i3_post50n_shreg_0 FIND v(xdut.x2.shreg_0) AT=0.00014705  $ shreg_0 at DATA-byte bit_index=3 (DATA (write)) edgepost50n
.measure tran rxe_i3_post50n_shreg_1 FIND v(xdut.x2.shreg_1) AT=0.00014705  $ shreg_1 at DATA-byte bit_index=3 (DATA (write)) edgepost50n
.measure tran rxe_i3_post50n_shreg_2 FIND v(xdut.x2.shreg_2) AT=0.00014705  $ shreg_2 at DATA-byte bit_index=3 (DATA (write)) edgepost50n
.measure tran rxe_i3_post50n_shreg_3 FIND v(xdut.x2.shreg_3) AT=0.00014705  $ shreg_3 at DATA-byte bit_index=3 (DATA (write)) edgepost50n
.measure tran rxe_i3_post50n_shreg_4 FIND v(xdut.x2.shreg_4) AT=0.00014705  $ shreg_4 at DATA-byte bit_index=3 (DATA (write)) edgepost50n
.measure tran rxe_i3_post50n_shreg_5 FIND v(xdut.x2.shreg_5) AT=0.00014705  $ shreg_5 at DATA-byte bit_index=3 (DATA (write)) edgepost50n
.measure tran rxe_i3_post50n_shreg_6 FIND v(xdut.x2.shreg_6) AT=0.00014705  $ shreg_6 at DATA-byte bit_index=3 (DATA (write)) edgepost50n
.measure tran rxe_i3_post50n_sda_in_row2 FIND v(xdut.x2.sda_in_row2) AT=0.00014705  $ sda_in_row2 at DATA-byte bit_index=3 (DATA (write)) edgepost50n
.measure tran rxe_i3_post50n_scl_row2 FIND v(xdut.x2.scl_row2) AT=0.00014705  $ scl_row2 at DATA-byte bit_index=3 (DATA (write)) edgepost50n
.measure tran rxe_i3_post500n_sel_087 FIND v(xdut.x2._087_) AT=0.0001475  $ sel_087 at DATA-byte bit_index=3 (DATA (write)) edgepost500n
.measure tran rxe_i3_post500n_last_bit_pending FIND v(xdut.x2.last_bit_pending) AT=0.0001475  $ last_bit_pending at DATA-byte bit_index=3 (DATA (write)) edgepost500n
.measure tran rxe_i3_post500n_shreg_0 FIND v(xdut.x2.shreg_0) AT=0.0001475  $ shreg_0 at DATA-byte bit_index=3 (DATA (write)) edgepost500n
.measure tran rxe_i3_post500n_shreg_1 FIND v(xdut.x2.shreg_1) AT=0.0001475  $ shreg_1 at DATA-byte bit_index=3 (DATA (write)) edgepost500n
.measure tran rxe_i3_post500n_shreg_2 FIND v(xdut.x2.shreg_2) AT=0.0001475  $ shreg_2 at DATA-byte bit_index=3 (DATA (write)) edgepost500n
.measure tran rxe_i3_post500n_shreg_3 FIND v(xdut.x2.shreg_3) AT=0.0001475  $ shreg_3 at DATA-byte bit_index=3 (DATA (write)) edgepost500n
.measure tran rxe_i3_post500n_shreg_4 FIND v(xdut.x2.shreg_4) AT=0.0001475  $ shreg_4 at DATA-byte bit_index=3 (DATA (write)) edgepost500n
.measure tran rxe_i3_post500n_shreg_5 FIND v(xdut.x2.shreg_5) AT=0.0001475  $ shreg_5 at DATA-byte bit_index=3 (DATA (write)) edgepost500n
.measure tran rxe_i3_post500n_shreg_6 FIND v(xdut.x2.shreg_6) AT=0.0001475  $ shreg_6 at DATA-byte bit_index=3 (DATA (write)) edgepost500n
.measure tran rxe_i3_post500n_sda_in_row2 FIND v(xdut.x2.sda_in_row2) AT=0.0001475  $ sda_in_row2 at DATA-byte bit_index=3 (DATA (write)) edgepost500n
.measure tran rxe_i3_post500n_scl_row2 FIND v(xdut.x2.scl_row2) AT=0.0001475  $ scl_row2 at DATA-byte bit_index=3 (DATA (write)) edgepost500n
.measure tran rxe_i2_pre50n_sel_087 FIND v(xdut.x2._087_) AT=0.00015695  $ sel_087 at DATA-byte bit_index=2 (DATA (write)) edgepre50n
.measure tran rxe_i2_pre50n_last_bit_pending FIND v(xdut.x2.last_bit_pending) AT=0.00015695  $ last_bit_pending at DATA-byte bit_index=2 (DATA (write)) edgepre50n
.measure tran rxe_i2_pre50n_shreg_0 FIND v(xdut.x2.shreg_0) AT=0.00015695  $ shreg_0 at DATA-byte bit_index=2 (DATA (write)) edgepre50n
.measure tran rxe_i2_pre50n_shreg_1 FIND v(xdut.x2.shreg_1) AT=0.00015695  $ shreg_1 at DATA-byte bit_index=2 (DATA (write)) edgepre50n
.measure tran rxe_i2_pre50n_shreg_2 FIND v(xdut.x2.shreg_2) AT=0.00015695  $ shreg_2 at DATA-byte bit_index=2 (DATA (write)) edgepre50n
.measure tran rxe_i2_pre50n_shreg_3 FIND v(xdut.x2.shreg_3) AT=0.00015695  $ shreg_3 at DATA-byte bit_index=2 (DATA (write)) edgepre50n
.measure tran rxe_i2_pre50n_shreg_4 FIND v(xdut.x2.shreg_4) AT=0.00015695  $ shreg_4 at DATA-byte bit_index=2 (DATA (write)) edgepre50n
.measure tran rxe_i2_pre50n_shreg_5 FIND v(xdut.x2.shreg_5) AT=0.00015695  $ shreg_5 at DATA-byte bit_index=2 (DATA (write)) edgepre50n
.measure tran rxe_i2_pre50n_shreg_6 FIND v(xdut.x2.shreg_6) AT=0.00015695  $ shreg_6 at DATA-byte bit_index=2 (DATA (write)) edgepre50n
.measure tran rxe_i2_pre50n_sda_in_row2 FIND v(xdut.x2.sda_in_row2) AT=0.00015695  $ sda_in_row2 at DATA-byte bit_index=2 (DATA (write)) edgepre50n
.measure tran rxe_i2_pre50n_scl_row2 FIND v(xdut.x2.scl_row2) AT=0.00015695  $ scl_row2 at DATA-byte bit_index=2 (DATA (write)) edgepre50n
.measure tran rxe_i2_post50n_sel_087 FIND v(xdut.x2._087_) AT=0.00015705  $ sel_087 at DATA-byte bit_index=2 (DATA (write)) edgepost50n
.measure tran rxe_i2_post50n_last_bit_pending FIND v(xdut.x2.last_bit_pending) AT=0.00015705  $ last_bit_pending at DATA-byte bit_index=2 (DATA (write)) edgepost50n
.measure tran rxe_i2_post50n_shreg_0 FIND v(xdut.x2.shreg_0) AT=0.00015705  $ shreg_0 at DATA-byte bit_index=2 (DATA (write)) edgepost50n
.measure tran rxe_i2_post50n_shreg_1 FIND v(xdut.x2.shreg_1) AT=0.00015705  $ shreg_1 at DATA-byte bit_index=2 (DATA (write)) edgepost50n
.measure tran rxe_i2_post50n_shreg_2 FIND v(xdut.x2.shreg_2) AT=0.00015705  $ shreg_2 at DATA-byte bit_index=2 (DATA (write)) edgepost50n
.measure tran rxe_i2_post50n_shreg_3 FIND v(xdut.x2.shreg_3) AT=0.00015705  $ shreg_3 at DATA-byte bit_index=2 (DATA (write)) edgepost50n
.measure tran rxe_i2_post50n_shreg_4 FIND v(xdut.x2.shreg_4) AT=0.00015705  $ shreg_4 at DATA-byte bit_index=2 (DATA (write)) edgepost50n
.measure tran rxe_i2_post50n_shreg_5 FIND v(xdut.x2.shreg_5) AT=0.00015705  $ shreg_5 at DATA-byte bit_index=2 (DATA (write)) edgepost50n
.measure tran rxe_i2_post50n_shreg_6 FIND v(xdut.x2.shreg_6) AT=0.00015705  $ shreg_6 at DATA-byte bit_index=2 (DATA (write)) edgepost50n
.measure tran rxe_i2_post50n_sda_in_row2 FIND v(xdut.x2.sda_in_row2) AT=0.00015705  $ sda_in_row2 at DATA-byte bit_index=2 (DATA (write)) edgepost50n
.measure tran rxe_i2_post50n_scl_row2 FIND v(xdut.x2.scl_row2) AT=0.00015705  $ scl_row2 at DATA-byte bit_index=2 (DATA (write)) edgepost50n
.measure tran rxe_i2_post500n_sel_087 FIND v(xdut.x2._087_) AT=0.0001575  $ sel_087 at DATA-byte bit_index=2 (DATA (write)) edgepost500n
.measure tran rxe_i2_post500n_last_bit_pending FIND v(xdut.x2.last_bit_pending) AT=0.0001575  $ last_bit_pending at DATA-byte bit_index=2 (DATA (write)) edgepost500n
.measure tran rxe_i2_post500n_shreg_0 FIND v(xdut.x2.shreg_0) AT=0.0001575  $ shreg_0 at DATA-byte bit_index=2 (DATA (write)) edgepost500n
.measure tran rxe_i2_post500n_shreg_1 FIND v(xdut.x2.shreg_1) AT=0.0001575  $ shreg_1 at DATA-byte bit_index=2 (DATA (write)) edgepost500n
.measure tran rxe_i2_post500n_shreg_2 FIND v(xdut.x2.shreg_2) AT=0.0001575  $ shreg_2 at DATA-byte bit_index=2 (DATA (write)) edgepost500n
.measure tran rxe_i2_post500n_shreg_3 FIND v(xdut.x2.shreg_3) AT=0.0001575  $ shreg_3 at DATA-byte bit_index=2 (DATA (write)) edgepost500n
.measure tran rxe_i2_post500n_shreg_4 FIND v(xdut.x2.shreg_4) AT=0.0001575  $ shreg_4 at DATA-byte bit_index=2 (DATA (write)) edgepost500n
.measure tran rxe_i2_post500n_shreg_5 FIND v(xdut.x2.shreg_5) AT=0.0001575  $ shreg_5 at DATA-byte bit_index=2 (DATA (write)) edgepost500n
.measure tran rxe_i2_post500n_shreg_6 FIND v(xdut.x2.shreg_6) AT=0.0001575  $ shreg_6 at DATA-byte bit_index=2 (DATA (write)) edgepost500n
.measure tran rxe_i2_post500n_sda_in_row2 FIND v(xdut.x2.sda_in_row2) AT=0.0001575  $ sda_in_row2 at DATA-byte bit_index=2 (DATA (write)) edgepost500n
.measure tran rxe_i2_post500n_scl_row2 FIND v(xdut.x2.scl_row2) AT=0.0001575  $ scl_row2 at DATA-byte bit_index=2 (DATA (write)) edgepost500n
.measure tran rxe_i1_pre50n_sel_087 FIND v(xdut.x2._087_) AT=0.00016695  $ sel_087 at DATA-byte bit_index=1 (DATA (write)) edgepre50n
.measure tran rxe_i1_pre50n_last_bit_pending FIND v(xdut.x2.last_bit_pending) AT=0.00016695  $ last_bit_pending at DATA-byte bit_index=1 (DATA (write)) edgepre50n
.measure tran rxe_i1_pre50n_shreg_0 FIND v(xdut.x2.shreg_0) AT=0.00016695  $ shreg_0 at DATA-byte bit_index=1 (DATA (write)) edgepre50n
.measure tran rxe_i1_pre50n_shreg_1 FIND v(xdut.x2.shreg_1) AT=0.00016695  $ shreg_1 at DATA-byte bit_index=1 (DATA (write)) edgepre50n
.measure tran rxe_i1_pre50n_shreg_2 FIND v(xdut.x2.shreg_2) AT=0.00016695  $ shreg_2 at DATA-byte bit_index=1 (DATA (write)) edgepre50n
.measure tran rxe_i1_pre50n_shreg_3 FIND v(xdut.x2.shreg_3) AT=0.00016695  $ shreg_3 at DATA-byte bit_index=1 (DATA (write)) edgepre50n
.measure tran rxe_i1_pre50n_shreg_4 FIND v(xdut.x2.shreg_4) AT=0.00016695  $ shreg_4 at DATA-byte bit_index=1 (DATA (write)) edgepre50n
.measure tran rxe_i1_pre50n_shreg_5 FIND v(xdut.x2.shreg_5) AT=0.00016695  $ shreg_5 at DATA-byte bit_index=1 (DATA (write)) edgepre50n
.measure tran rxe_i1_pre50n_shreg_6 FIND v(xdut.x2.shreg_6) AT=0.00016695  $ shreg_6 at DATA-byte bit_index=1 (DATA (write)) edgepre50n
.measure tran rxe_i1_pre50n_sda_in_row2 FIND v(xdut.x2.sda_in_row2) AT=0.00016695  $ sda_in_row2 at DATA-byte bit_index=1 (DATA (write)) edgepre50n
.measure tran rxe_i1_pre50n_scl_row2 FIND v(xdut.x2.scl_row2) AT=0.00016695  $ scl_row2 at DATA-byte bit_index=1 (DATA (write)) edgepre50n
.measure tran rxe_i1_post50n_sel_087 FIND v(xdut.x2._087_) AT=0.00016705  $ sel_087 at DATA-byte bit_index=1 (DATA (write)) edgepost50n
.measure tran rxe_i1_post50n_last_bit_pending FIND v(xdut.x2.last_bit_pending) AT=0.00016705  $ last_bit_pending at DATA-byte bit_index=1 (DATA (write)) edgepost50n
.measure tran rxe_i1_post50n_shreg_0 FIND v(xdut.x2.shreg_0) AT=0.00016705  $ shreg_0 at DATA-byte bit_index=1 (DATA (write)) edgepost50n
.measure tran rxe_i1_post50n_shreg_1 FIND v(xdut.x2.shreg_1) AT=0.00016705  $ shreg_1 at DATA-byte bit_index=1 (DATA (write)) edgepost50n
.measure tran rxe_i1_post50n_shreg_2 FIND v(xdut.x2.shreg_2) AT=0.00016705  $ shreg_2 at DATA-byte bit_index=1 (DATA (write)) edgepost50n
.measure tran rxe_i1_post50n_shreg_3 FIND v(xdut.x2.shreg_3) AT=0.00016705  $ shreg_3 at DATA-byte bit_index=1 (DATA (write)) edgepost50n
.measure tran rxe_i1_post50n_shreg_4 FIND v(xdut.x2.shreg_4) AT=0.00016705  $ shreg_4 at DATA-byte bit_index=1 (DATA (write)) edgepost50n
.measure tran rxe_i1_post50n_shreg_5 FIND v(xdut.x2.shreg_5) AT=0.00016705  $ shreg_5 at DATA-byte bit_index=1 (DATA (write)) edgepost50n
.measure tran rxe_i1_post50n_shreg_6 FIND v(xdut.x2.shreg_6) AT=0.00016705  $ shreg_6 at DATA-byte bit_index=1 (DATA (write)) edgepost50n
.measure tran rxe_i1_post50n_sda_in_row2 FIND v(xdut.x2.sda_in_row2) AT=0.00016705  $ sda_in_row2 at DATA-byte bit_index=1 (DATA (write)) edgepost50n
.measure tran rxe_i1_post50n_scl_row2 FIND v(xdut.x2.scl_row2) AT=0.00016705  $ scl_row2 at DATA-byte bit_index=1 (DATA (write)) edgepost50n
.measure tran rxe_i1_post500n_sel_087 FIND v(xdut.x2._087_) AT=0.0001675  $ sel_087 at DATA-byte bit_index=1 (DATA (write)) edgepost500n
.measure tran rxe_i1_post500n_last_bit_pending FIND v(xdut.x2.last_bit_pending) AT=0.0001675  $ last_bit_pending at DATA-byte bit_index=1 (DATA (write)) edgepost500n
.measure tran rxe_i1_post500n_shreg_0 FIND v(xdut.x2.shreg_0) AT=0.0001675  $ shreg_0 at DATA-byte bit_index=1 (DATA (write)) edgepost500n
.measure tran rxe_i1_post500n_shreg_1 FIND v(xdut.x2.shreg_1) AT=0.0001675  $ shreg_1 at DATA-byte bit_index=1 (DATA (write)) edgepost500n
.measure tran rxe_i1_post500n_shreg_2 FIND v(xdut.x2.shreg_2) AT=0.0001675  $ shreg_2 at DATA-byte bit_index=1 (DATA (write)) edgepost500n
.measure tran rxe_i1_post500n_shreg_3 FIND v(xdut.x2.shreg_3) AT=0.0001675  $ shreg_3 at DATA-byte bit_index=1 (DATA (write)) edgepost500n
.measure tran rxe_i1_post500n_shreg_4 FIND v(xdut.x2.shreg_4) AT=0.0001675  $ shreg_4 at DATA-byte bit_index=1 (DATA (write)) edgepost500n
.measure tran rxe_i1_post500n_shreg_5 FIND v(xdut.x2.shreg_5) AT=0.0001675  $ shreg_5 at DATA-byte bit_index=1 (DATA (write)) edgepost500n
.measure tran rxe_i1_post500n_shreg_6 FIND v(xdut.x2.shreg_6) AT=0.0001675  $ shreg_6 at DATA-byte bit_index=1 (DATA (write)) edgepost500n
.measure tran rxe_i1_post500n_sda_in_row2 FIND v(xdut.x2.sda_in_row2) AT=0.0001675  $ sda_in_row2 at DATA-byte bit_index=1 (DATA (write)) edgepost500n
.measure tran rxe_i1_post500n_scl_row2 FIND v(xdut.x2.scl_row2) AT=0.0001675  $ scl_row2 at DATA-byte bit_index=1 (DATA (write)) edgepost500n
.measure tran rxe_i0_pre50n_sel_087 FIND v(xdut.x2._087_) AT=0.00017695  $ sel_087 at DATA-byte bit_index=0 (DATA (write)) edgepre50n
.measure tran rxe_i0_pre50n_last_bit_pending FIND v(xdut.x2.last_bit_pending) AT=0.00017695  $ last_bit_pending at DATA-byte bit_index=0 (DATA (write)) edgepre50n
.measure tran rxe_i0_pre50n_shreg_0 FIND v(xdut.x2.shreg_0) AT=0.00017695  $ shreg_0 at DATA-byte bit_index=0 (DATA (write)) edgepre50n
.measure tran rxe_i0_pre50n_shreg_1 FIND v(xdut.x2.shreg_1) AT=0.00017695  $ shreg_1 at DATA-byte bit_index=0 (DATA (write)) edgepre50n
.measure tran rxe_i0_pre50n_shreg_2 FIND v(xdut.x2.shreg_2) AT=0.00017695  $ shreg_2 at DATA-byte bit_index=0 (DATA (write)) edgepre50n
.measure tran rxe_i0_pre50n_shreg_3 FIND v(xdut.x2.shreg_3) AT=0.00017695  $ shreg_3 at DATA-byte bit_index=0 (DATA (write)) edgepre50n
.measure tran rxe_i0_pre50n_shreg_4 FIND v(xdut.x2.shreg_4) AT=0.00017695  $ shreg_4 at DATA-byte bit_index=0 (DATA (write)) edgepre50n
.measure tran rxe_i0_pre50n_shreg_5 FIND v(xdut.x2.shreg_5) AT=0.00017695  $ shreg_5 at DATA-byte bit_index=0 (DATA (write)) edgepre50n
.measure tran rxe_i0_pre50n_shreg_6 FIND v(xdut.x2.shreg_6) AT=0.00017695  $ shreg_6 at DATA-byte bit_index=0 (DATA (write)) edgepre50n
.measure tran rxe_i0_pre50n_sda_in_row2 FIND v(xdut.x2.sda_in_row2) AT=0.00017695  $ sda_in_row2 at DATA-byte bit_index=0 (DATA (write)) edgepre50n
.measure tran rxe_i0_pre50n_scl_row2 FIND v(xdut.x2.scl_row2) AT=0.00017695  $ scl_row2 at DATA-byte bit_index=0 (DATA (write)) edgepre50n
.measure tran rxe_i0_post50n_sel_087 FIND v(xdut.x2._087_) AT=0.00017705  $ sel_087 at DATA-byte bit_index=0 (DATA (write)) edgepost50n
.measure tran rxe_i0_post50n_last_bit_pending FIND v(xdut.x2.last_bit_pending) AT=0.00017705  $ last_bit_pending at DATA-byte bit_index=0 (DATA (write)) edgepost50n
.measure tran rxe_i0_post50n_shreg_0 FIND v(xdut.x2.shreg_0) AT=0.00017705  $ shreg_0 at DATA-byte bit_index=0 (DATA (write)) edgepost50n
.measure tran rxe_i0_post50n_shreg_1 FIND v(xdut.x2.shreg_1) AT=0.00017705  $ shreg_1 at DATA-byte bit_index=0 (DATA (write)) edgepost50n
.measure tran rxe_i0_post50n_shreg_2 FIND v(xdut.x2.shreg_2) AT=0.00017705  $ shreg_2 at DATA-byte bit_index=0 (DATA (write)) edgepost50n
.measure tran rxe_i0_post50n_shreg_3 FIND v(xdut.x2.shreg_3) AT=0.00017705  $ shreg_3 at DATA-byte bit_index=0 (DATA (write)) edgepost50n
.measure tran rxe_i0_post50n_shreg_4 FIND v(xdut.x2.shreg_4) AT=0.00017705  $ shreg_4 at DATA-byte bit_index=0 (DATA (write)) edgepost50n
.measure tran rxe_i0_post50n_shreg_5 FIND v(xdut.x2.shreg_5) AT=0.00017705  $ shreg_5 at DATA-byte bit_index=0 (DATA (write)) edgepost50n
.measure tran rxe_i0_post50n_shreg_6 FIND v(xdut.x2.shreg_6) AT=0.00017705  $ shreg_6 at DATA-byte bit_index=0 (DATA (write)) edgepost50n
.measure tran rxe_i0_post50n_sda_in_row2 FIND v(xdut.x2.sda_in_row2) AT=0.00017705  $ sda_in_row2 at DATA-byte bit_index=0 (DATA (write)) edgepost50n
.measure tran rxe_i0_post50n_scl_row2 FIND v(xdut.x2.scl_row2) AT=0.00017705  $ scl_row2 at DATA-byte bit_index=0 (DATA (write)) edgepost50n
.measure tran rxe_i0_post500n_sel_087 FIND v(xdut.x2._087_) AT=0.0001775  $ sel_087 at DATA-byte bit_index=0 (DATA (write)) edgepost500n
.measure tran rxe_i0_post500n_last_bit_pending FIND v(xdut.x2.last_bit_pending) AT=0.0001775  $ last_bit_pending at DATA-byte bit_index=0 (DATA (write)) edgepost500n
.measure tran rxe_i0_post500n_shreg_0 FIND v(xdut.x2.shreg_0) AT=0.0001775  $ shreg_0 at DATA-byte bit_index=0 (DATA (write)) edgepost500n
.measure tran rxe_i0_post500n_shreg_1 FIND v(xdut.x2.shreg_1) AT=0.0001775  $ shreg_1 at DATA-byte bit_index=0 (DATA (write)) edgepost500n
.measure tran rxe_i0_post500n_shreg_2 FIND v(xdut.x2.shreg_2) AT=0.0001775  $ shreg_2 at DATA-byte bit_index=0 (DATA (write)) edgepost500n
.measure tran rxe_i0_post500n_shreg_3 FIND v(xdut.x2.shreg_3) AT=0.0001775  $ shreg_3 at DATA-byte bit_index=0 (DATA (write)) edgepost500n
.measure tran rxe_i0_post500n_shreg_4 FIND v(xdut.x2.shreg_4) AT=0.0001775  $ shreg_4 at DATA-byte bit_index=0 (DATA (write)) edgepost500n
.measure tran rxe_i0_post500n_shreg_5 FIND v(xdut.x2.shreg_5) AT=0.0001775  $ shreg_5 at DATA-byte bit_index=0 (DATA (write)) edgepost500n
.measure tran rxe_i0_post500n_shreg_6 FIND v(xdut.x2.shreg_6) AT=0.0001775  $ shreg_6 at DATA-byte bit_index=0 (DATA (write)) edgepost500n
.measure tran rxe_i0_post500n_sda_in_row2 FIND v(xdut.x2.sda_in_row2) AT=0.0001775  $ sda_in_row2 at DATA-byte bit_index=0 (DATA (write)) edgepost500n
.measure tran rxe_i0_post500n_scl_row2 FIND v(xdut.x2.scl_row2) AT=0.0001775  $ scl_row2 at DATA-byte bit_index=0 (DATA (write)) edgepost500n
.measure tran rxdiag_shreg_0 FIND v(xdut.x2.shreg_0) AT=0.000194  $ shreg_0 at rx_data sample time
.measure tran rxdiag_shreg_1 FIND v(xdut.x2.shreg_1) AT=0.000194  $ shreg_1 at rx_data sample time
.measure tran rxdiag_shreg_2 FIND v(xdut.x2.shreg_2) AT=0.000194  $ shreg_2 at rx_data sample time
.measure tran rxdiag_shreg_3 FIND v(xdut.x2.shreg_3) AT=0.000194  $ shreg_3 at rx_data sample time
.measure tran rxdiag_shreg_4 FIND v(xdut.x2.shreg_4) AT=0.000194  $ shreg_4 at rx_data sample time
.measure tran rxdiag_shreg_5 FIND v(xdut.x2.shreg_5) AT=0.000194  $ shreg_5 at rx_data sample time
.measure tran rxdiag_shreg_6 FIND v(xdut.x2.shreg_6) AT=0.000194  $ shreg_6 at rx_data sample time
.measure tran rxdiag_sda_in_row2 FIND v(xdut.x2.sda_in_row2) AT=0.000194  $ sda_in_row2 at rx_data sample time
.measure tran rxdiag_nc_out3 FIND v(xdut.NC_OUT3) AT=0.000194  $ nc_out3 at rx_data sample time
.measure tran rxdiag_nc_out4 FIND v(xdut.NC_OUT4) AT=0.000194  $ nc_out4 at rx_data sample time
.measure tran rxdiag_nc_out5 FIND v(xdut.NC_OUT5) AT=0.000194  $ nc_out5 at rx_data sample time
.measure tran rxdiag_nc_out6 FIND v(xdut.NC_OUT6) AT=0.000194  $ nc_out6 at rx_data sample time
.measure tran rxdiag_nc_out11 FIND v(xdut.NC_OUT11) AT=0.000194  $ nc_out11 at rx_data sample time
.measure tran rxdiag_nc_out12 FIND v(xdut.NC_OUT12) AT=0.000194  $ nc_out12 at rx_data sample time
.measure tran rxdiag_nc_out13 FIND v(xdut.NC_OUT13) AT=0.000194  $ nc_out13 at rx_data sample time
.measure tran rxdiag_nc_out14 FIND v(xdut.NC_OUT14) AT=0.000194  $ nc_out14 at rx_data sample time
.measure tran stop1_busy_m500n FIND v(xdut.NC_CORE_busy) AT=0.0002015  $ busy at STOP1-500ns
.measure tran stop1_busy_clr_m500n FIND v(xdut.x2._077_) AT=0.0002015  $ busy_clr at STOP1-500ns
.measure tran stop1_qn_m500n FIND v(xdut.x2.qn) AT=0.0002015  $ qn at STOP1-500ns
.measure tran stop1_scl_row2_m500n FIND v(xdut.x2.scl_row2) AT=0.0002015  $ scl_row2 at STOP1-500ns
.measure tran stop1_sda_in_row2_m500n FIND v(xdut.x2.sda_in_row2) AT=0.0002015  $ sda_in_row2 at STOP1-500ns
.measure tran stop1_sda_d_m500n FIND v(xdut.x2.sda_d) AT=0.0002015  $ sda_d at STOP1-500ns
.measure tran stop1_busy_m100n FIND v(xdut.NC_CORE_busy) AT=0.0002019  $ busy at STOP1-100ns
.measure tran stop1_busy_clr_m100n FIND v(xdut.x2._077_) AT=0.0002019  $ busy_clr at STOP1-100ns
.measure tran stop1_qn_m100n FIND v(xdut.x2.qn) AT=0.0002019  $ qn at STOP1-100ns
.measure tran stop1_scl_row2_m100n FIND v(xdut.x2.scl_row2) AT=0.0002019  $ scl_row2 at STOP1-100ns
.measure tran stop1_sda_in_row2_m100n FIND v(xdut.x2.sda_in_row2) AT=0.0002019  $ sda_in_row2 at STOP1-100ns
.measure tran stop1_sda_d_m100n FIND v(xdut.x2.sda_d) AT=0.0002019  $ sda_d at STOP1-100ns
.measure tran stop1_busy_m50n FIND v(xdut.NC_CORE_busy) AT=0.00020195  $ busy at STOP1-50ns
.measure tran stop1_busy_clr_m50n FIND v(xdut.x2._077_) AT=0.00020195  $ busy_clr at STOP1-50ns
.measure tran stop1_qn_m50n FIND v(xdut.x2.qn) AT=0.00020195  $ qn at STOP1-50ns
.measure tran stop1_scl_row2_m50n FIND v(xdut.x2.scl_row2) AT=0.00020195  $ scl_row2 at STOP1-50ns
.measure tran stop1_sda_in_row2_m50n FIND v(xdut.x2.sda_in_row2) AT=0.00020195  $ sda_in_row2 at STOP1-50ns
.measure tran stop1_sda_d_m50n FIND v(xdut.x2.sda_d) AT=0.00020195  $ sda_d at STOP1-50ns
.measure tran stop1_busy_m20n FIND v(xdut.NC_CORE_busy) AT=0.00020198  $ busy at STOP1-20ns
.measure tran stop1_busy_clr_m20n FIND v(xdut.x2._077_) AT=0.00020198  $ busy_clr at STOP1-20ns
.measure tran stop1_qn_m20n FIND v(xdut.x2.qn) AT=0.00020198  $ qn at STOP1-20ns
.measure tran stop1_scl_row2_m20n FIND v(xdut.x2.scl_row2) AT=0.00020198  $ scl_row2 at STOP1-20ns
.measure tran stop1_sda_in_row2_m20n FIND v(xdut.x2.sda_in_row2) AT=0.00020198  $ sda_in_row2 at STOP1-20ns
.measure tran stop1_sda_d_m20n FIND v(xdut.x2.sda_d) AT=0.00020198  $ sda_d at STOP1-20ns
.measure tran stop1_busy_m10n FIND v(xdut.NC_CORE_busy) AT=0.00020199  $ busy at STOP1-10ns
.measure tran stop1_busy_clr_m10n FIND v(xdut.x2._077_) AT=0.00020199  $ busy_clr at STOP1-10ns
.measure tran stop1_qn_m10n FIND v(xdut.x2.qn) AT=0.00020199  $ qn at STOP1-10ns
.measure tran stop1_scl_row2_m10n FIND v(xdut.x2.scl_row2) AT=0.00020199  $ scl_row2 at STOP1-10ns
.measure tran stop1_sda_in_row2_m10n FIND v(xdut.x2.sda_in_row2) AT=0.00020199  $ sda_in_row2 at STOP1-10ns
.measure tran stop1_sda_d_m10n FIND v(xdut.x2.sda_d) AT=0.00020199  $ sda_d at STOP1-10ns
.measure tran stop1_busy_m5n FIND v(xdut.NC_CORE_busy) AT=0.000201995  $ busy at STOP1-5ns
.measure tran stop1_busy_clr_m5n FIND v(xdut.x2._077_) AT=0.000201995  $ busy_clr at STOP1-5ns
.measure tran stop1_qn_m5n FIND v(xdut.x2.qn) AT=0.000201995  $ qn at STOP1-5ns
.measure tran stop1_scl_row2_m5n FIND v(xdut.x2.scl_row2) AT=0.000201995  $ scl_row2 at STOP1-5ns
.measure tran stop1_sda_in_row2_m5n FIND v(xdut.x2.sda_in_row2) AT=0.000201995  $ sda_in_row2 at STOP1-5ns
.measure tran stop1_sda_d_m5n FIND v(xdut.x2.sda_d) AT=0.000201995  $ sda_d at STOP1-5ns
.measure tran stop1_busy_evt FIND v(xdut.NC_CORE_busy) AT=0.000202  $ busy at STOP1+0ns
.measure tran stop1_busy_clr_evt FIND v(xdut.x2._077_) AT=0.000202  $ busy_clr at STOP1+0ns
.measure tran stop1_qn_evt FIND v(xdut.x2.qn) AT=0.000202  $ qn at STOP1+0ns
.measure tran stop1_scl_row2_evt FIND v(xdut.x2.scl_row2) AT=0.000202  $ scl_row2 at STOP1+0ns
.measure tran stop1_sda_in_row2_evt FIND v(xdut.x2.sda_in_row2) AT=0.000202  $ sda_in_row2 at STOP1+0ns
.measure tran stop1_sda_d_evt FIND v(xdut.x2.sda_d) AT=0.000202  $ sda_d at STOP1+0ns
.measure tran stop1_busy_p5n FIND v(xdut.NC_CORE_busy) AT=0.000202005  $ busy at STOP1+5ns
.measure tran stop1_busy_clr_p5n FIND v(xdut.x2._077_) AT=0.000202005  $ busy_clr at STOP1+5ns
.measure tran stop1_qn_p5n FIND v(xdut.x2.qn) AT=0.000202005  $ qn at STOP1+5ns
.measure tran stop1_scl_row2_p5n FIND v(xdut.x2.scl_row2) AT=0.000202005  $ scl_row2 at STOP1+5ns
.measure tran stop1_sda_in_row2_p5n FIND v(xdut.x2.sda_in_row2) AT=0.000202005  $ sda_in_row2 at STOP1+5ns
.measure tran stop1_sda_d_p5n FIND v(xdut.x2.sda_d) AT=0.000202005  $ sda_d at STOP1+5ns
.measure tran stop1_busy_p10n FIND v(xdut.NC_CORE_busy) AT=0.00020201  $ busy at STOP1+10ns
.measure tran stop1_busy_clr_p10n FIND v(xdut.x2._077_) AT=0.00020201  $ busy_clr at STOP1+10ns
.measure tran stop1_qn_p10n FIND v(xdut.x2.qn) AT=0.00020201  $ qn at STOP1+10ns
.measure tran stop1_scl_row2_p10n FIND v(xdut.x2.scl_row2) AT=0.00020201  $ scl_row2 at STOP1+10ns
.measure tran stop1_sda_in_row2_p10n FIND v(xdut.x2.sda_in_row2) AT=0.00020201  $ sda_in_row2 at STOP1+10ns
.measure tran stop1_sda_d_p10n FIND v(xdut.x2.sda_d) AT=0.00020201  $ sda_d at STOP1+10ns
.measure tran stop1_busy_p20n FIND v(xdut.NC_CORE_busy) AT=0.00020202  $ busy at STOP1+20ns
.measure tran stop1_busy_clr_p20n FIND v(xdut.x2._077_) AT=0.00020202  $ busy_clr at STOP1+20ns
.measure tran stop1_qn_p20n FIND v(xdut.x2.qn) AT=0.00020202  $ qn at STOP1+20ns
.measure tran stop1_scl_row2_p20n FIND v(xdut.x2.scl_row2) AT=0.00020202  $ scl_row2 at STOP1+20ns
.measure tran stop1_sda_in_row2_p20n FIND v(xdut.x2.sda_in_row2) AT=0.00020202  $ sda_in_row2 at STOP1+20ns
.measure tran stop1_sda_d_p20n FIND v(xdut.x2.sda_d) AT=0.00020202  $ sda_d at STOP1+20ns
.measure tran stop1_busy_p50n FIND v(xdut.NC_CORE_busy) AT=0.00020205  $ busy at STOP1+50ns
.measure tran stop1_busy_clr_p50n FIND v(xdut.x2._077_) AT=0.00020205  $ busy_clr at STOP1+50ns
.measure tran stop1_qn_p50n FIND v(xdut.x2.qn) AT=0.00020205  $ qn at STOP1+50ns
.measure tran stop1_scl_row2_p50n FIND v(xdut.x2.scl_row2) AT=0.00020205  $ scl_row2 at STOP1+50ns
.measure tran stop1_sda_in_row2_p50n FIND v(xdut.x2.sda_in_row2) AT=0.00020205  $ sda_in_row2 at STOP1+50ns
.measure tran stop1_sda_d_p50n FIND v(xdut.x2.sda_d) AT=0.00020205  $ sda_d at STOP1+50ns
.measure tran stop1_busy_p100n FIND v(xdut.NC_CORE_busy) AT=0.0002021  $ busy at STOP1+100ns
.measure tran stop1_busy_clr_p100n FIND v(xdut.x2._077_) AT=0.0002021  $ busy_clr at STOP1+100ns
.measure tran stop1_qn_p100n FIND v(xdut.x2.qn) AT=0.0002021  $ qn at STOP1+100ns
.measure tran stop1_scl_row2_p100n FIND v(xdut.x2.scl_row2) AT=0.0002021  $ scl_row2 at STOP1+100ns
.measure tran stop1_sda_in_row2_p100n FIND v(xdut.x2.sda_in_row2) AT=0.0002021  $ sda_in_row2 at STOP1+100ns
.measure tran stop1_sda_d_p100n FIND v(xdut.x2.sda_d) AT=0.0002021  $ sda_d at STOP1+100ns
.measure tran stop1_busy_p500n FIND v(xdut.NC_CORE_busy) AT=0.0002025  $ busy at STOP1+500ns
.measure tran stop1_busy_clr_p500n FIND v(xdut.x2._077_) AT=0.0002025  $ busy_clr at STOP1+500ns
.measure tran stop1_qn_p500n FIND v(xdut.x2.qn) AT=0.0002025  $ qn at STOP1+500ns
.measure tran stop1_scl_row2_p500n FIND v(xdut.x2.scl_row2) AT=0.0002025  $ scl_row2 at STOP1+500ns
.measure tran stop1_sda_in_row2_p500n FIND v(xdut.x2.sda_in_row2) AT=0.0002025  $ sda_in_row2 at STOP1+500ns
.measure tran stop1_sda_d_p500n FIND v(xdut.x2.sda_d) AT=0.0002025  $ sda_d at STOP1+500ns
.measure tran stop1_busy_p1u FIND v(xdut.NC_CORE_busy) AT=0.000203  $ busy at STOP1+1000ns
.measure tran stop1_busy_clr_p1u FIND v(xdut.x2._077_) AT=0.000203  $ busy_clr at STOP1+1000ns
.measure tran stop1_qn_p1u FIND v(xdut.x2.qn) AT=0.000203  $ qn at STOP1+1000ns
.measure tran stop1_scl_row2_p1u FIND v(xdut.x2.scl_row2) AT=0.000203  $ scl_row2 at STOP1+1000ns
.measure tran stop1_sda_in_row2_p1u FIND v(xdut.x2.sda_in_row2) AT=0.000203  $ sda_in_row2 at STOP1+1000ns
.measure tran stop1_sda_d_p1u FIND v(xdut.x2.sda_d) AT=0.000203  $ sda_d at STOP1+1000ns
.measure tran stop1_busy_p2u FIND v(xdut.NC_CORE_busy) AT=0.000204  $ busy at STOP1+2000ns
.measure tran stop1_busy_clr_p2u FIND v(xdut.x2._077_) AT=0.000204  $ busy_clr at STOP1+2000ns
.measure tran stop1_qn_p2u FIND v(xdut.x2.qn) AT=0.000204  $ qn at STOP1+2000ns
.measure tran stop1_scl_row2_p2u FIND v(xdut.x2.scl_row2) AT=0.000204  $ scl_row2 at STOP1+2000ns
.measure tran stop1_sda_in_row2_p2u FIND v(xdut.x2.sda_in_row2) AT=0.000204  $ sda_in_row2 at STOP1+2000ns
.measure tran stop1_sda_d_p2u FIND v(xdut.x2.sda_d) AT=0.000204  $ sda_d at STOP1+2000ns
.measure tran stop1_busy_p5u FIND v(xdut.NC_CORE_busy) AT=0.000207  $ busy at STOP1+5000ns
.measure tran stop1_busy_clr_p5u FIND v(xdut.x2._077_) AT=0.000207  $ busy_clr at STOP1+5000ns
.measure tran stop1_qn_p5u FIND v(xdut.x2.qn) AT=0.000207  $ qn at STOP1+5000ns
.measure tran stop1_scl_row2_p5u FIND v(xdut.x2.scl_row2) AT=0.000207  $ scl_row2 at STOP1+5000ns
.measure tran stop1_sda_in_row2_p5u FIND v(xdut.x2.sda_in_row2) AT=0.000207  $ sda_in_row2 at STOP1+5000ns
.measure tran stop1_sda_d_p5u FIND v(xdut.x2.sda_d) AT=0.000207  $ sda_d at STOP1+5000ns

* 2026-09-02 fix (design_notes.md section 108.12): do NOT issue any
* explicit `print <names>` command here. ngspice already auto-prints every
* `.measure` result once, immediately after `run` finishes, in its own
* "Measurements for Transient Analysis" block -- that block is the single,
* clean, uncorrupted source of truth check_batch14.py needs (it just
* regexes "name = value" lines out of the whole log). Issuing our own
* `print` commands afterward (even split into small chunks -- chunk size
* was NOT the cause, see 108.11/108.12) was empirically found to trigger a
* real ngspice batch-mode bug: `Warning from checkvalid: vector ... is not
* available or has zero length` followed by `Warning: can't parse
* '<netname>': ignored`, and then ngspice silently RE-RUNS the entire
* `.tran` analysis a second time from scratch, printing a SECOND
* "Measurements for Transient Analysis" block whose values do not match
* the first (confirmed via `xdut.x2.shreg_N`, which held a stable, sane
* bit pattern in both duplicate runs, while `NC_OUTxx`/`rx_data_bitN`
* swung between all-5V and all-0V between the two -- i.e. the corrupted
* second pass, not the real circuit, is what produced the nonsense
* "rx_data" byte). check_batch14.py's parser keeps the LAST "name=value"
* match per name, so it was silently picking up the corrupted second run.
* Removing `print` avoids triggering the second run entirely.
.control
  save all
  run
* 2026-09-02 fix (design_notes.md section 108.16): the original version of
* this line used `v(xdut.x2.rx_data_N)` -- the SAME mistake already
* diagnosed and fixed once in 108.10 for the .measure-based checks
* (rx_data_N is a subckt PORT, so ngspice's flattening merges it into the
* caller-side net NC_OUTxx; `xdut.x2.rx_data_N` does not exist as a
* vector). Using it here caused a hard "Error: no such vector" that
* silently aborted this entire `wrdata` command, so no trace file was
* ever written. Fixed to use the correct `xdut.NC_OUTxx` aliases
* (bit0..7 = NC_OUT11/12/13/14/6/5/4/3, per RX_NET_BY_BIT above).
* 2026-09-02 addition (design_notes.md section 108.17): add the 3 actual
* per-row-buffered DFFRB clock nets (`_156__row1/2/3`) -- the earlier
* version of this dump only had `scl_row2` (a DIFFERENT signal, used by
* the START/STOP detector, not the rx_data DFFRBs' own clock input) by
* mistake, so it could not actually show whether `_156__row3` (which
* clocks 7 of the 8 rx_data DFFRBs, vs `_156__row2` for just rx_data_0)
* is toggling at all.
* 2026-09-02 addition (design_notes.md section 108.21): after the 108.20
* row-buffer reassignment fixed rx_data, a NEW, previously-unseen failure
* appeared on "read byte == 0x3C" (got 0x3E, differs only in weight-bit1,
* i.e. the 7th bit shifted out, sampled while bit_cnt==6). Static netlist
* tracing shows the tx-side bit-select network (txreg_0..7, the MUX2 tree
* x_455_/457_/461_/462_/463_, `_092_`/`_079_`/`_005_`) has NO combinational
* or clock dependency on `_156__row0`/`_156__row3` (it lives on the
* completely separate `scl_n_row0`/`scl_n_row2` negedge-domain clock
* trees) -- so this is not explained by the 108.20 patch through any
* logical fan-in we can find by inspection. Adding these nets to the trace
* to check empirically whether it is a genuine tx-path bug (independent of
* 108.20) or a timing-margin issue in that separate clock domain.
  wrdata rx_capture_trace.txt v(xdut.x2.shreg_0) v(xdut.x2.shreg_1) v(xdut.x2.shreg_2) v(xdut.x2.shreg_3) v(xdut.x2.shreg_4) v(xdut.x2.shreg_5) v(xdut.x2.shreg_6) v(xdut.x2.sda_in_row2) v(xdut.x2._087_) v(xdut.x2.last_bit_pending) v(xdut.x2._156__row0) v(xdut.x2._156__row1) v(xdut.x2._156__row2) v(xdut.x2._156__row3) v(xdut.x2._016_) v(xdut.x2.bit_cnt_0) v(xdut.x2.bit_cnt_1) v(xdut.x2.bit_cnt_2) v(xdut.NC_CORE_busy) v(xdut.NC_OUT11) v(xdut.NC_OUT12) v(xdut.NC_OUT13) v(xdut.NC_OUT14) v(xdut.NC_OUT6) v(xdut.NC_OUT5) v(xdut.NC_OUT4) v(xdut.NC_OUT3) v(xdut.x2.txreg_0) v(xdut.x2.txreg_1) v(xdut.x2.txreg_2) v(xdut.x2.txreg_3) v(xdut.x2.txreg_4) v(xdut.x2.txreg_5) v(xdut.x2.txreg_6) v(xdut.x2.txreg_7) v(xdut.x2._092_) v(xdut.x2._079_) v(xdut.x2._005_) v(xdut.x2.sda_oe_r) v(xdut.x2.scl_n_row0) v(xdut.x2.scl_n_row2) v(xdut.x2.scl_n_row3) v(xdut.x2.scl_n)
.endc

.end
