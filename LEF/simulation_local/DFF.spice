** sch_path: /Users/okamura/Dropbox/98_LSI_Design/TR-1um_Async_I2C/LEF/DFF.sch
.subckt DFF VDD QB D Q GND CK
*.PININFO VDD:B GND:B D:I Q:O QB:O CK:I
MM2 net1 D VDD VDD PMOS w=5.2u l=1u
MM1 net2 CKP net1 VDD PMOS w=5.2u l=1u
MM7 net2 CKB net3 GND NMOS w=3.4u l=1u
MM8 net3 D GND GND NMOS w=3.4u l=1u
MM10 QM net2 VDD VDD PMOS w=5.2u l=1u
MM11 QM net2 GND GND NMOS w=3.4u l=1u
MM13 net4 QM GND GND NMOS w=3.4u l=1u
MM15 net4 CKP net2 GND NMOS w=3.4u l=1u
MM22 QB QS VDD VDD PMOS w=10.4u l=1u
MM3 net4 QM VDD VDD PMOS w=5.2u l=1u
MM4 net2 CKB net4 VDD PMOS w=5.2u l=1u
MM5 QS CKP QM GND NMOS w=3.4u l=1u
MM6 QM CKB QS VDD PMOS w=5.2u l=1u
MM9 net5 QB GND GND NMOS w=3.4u l=1u
MM12 net5 QB VDD VDD PMOS w=5.2u l=1u
MM14 net5 CKB QS GND NMOS w=3.4u l=1u
MM16 QS CKP net5 VDD PMOS w=5.2u l=1u
MM17 QB QS GND GND NMOS w=3.4u l=1u
MM18 Q QB VDD VDD PMOS w=10.4u l=1u
MM19 Q QB GND GND NMOS w=3.4u l=1u
MM20 CKB CK VDD VDD PMOS w=10.4u l=1u
MM21 CKB CK GND GND NMOS w=3.4u l=1u
MM23 CKP CKB VDD VDD PMOS w=10.4u l=1u
MM24 CKP CKB GND GND NMOS w=3.4u l=1u
.ends
