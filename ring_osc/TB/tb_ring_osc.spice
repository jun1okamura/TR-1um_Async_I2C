* tb_ring_osc.spice -- auto-generated by script/gen_ring_osc_tb.py
* DO NOT hand-edit -- regenerate instead.
*
* Standalone RING_OSC testbench: measures free-running oscillation
* frequency/period of both rings (OUT, OUTB=OUTD) and VDD supply
* current, using the real TR-1um transistor models (same ones used to
* calibrate irsim/TR-1um.prm -- see script/gen_prm_characterize.py) and
* the LAYOUT-EXTRACTED RING_OSC netlist (RING_OSC_extracted_sim_ready.
* spice -- verbatim copy of ring_osc/RING_OSC.extracted, real per-device
* extracted parasitics, see gen_ring_osc_tb.py's own header for why this
* replaced the earlier schematic-based revision).

.include '~/Dropbox/91_OpenPDK/TR-1um/libs.tech/spice/models/ip62_models'
.include 'RING_OSC_extracted_sim_ready.spice'

* NOTE: ground rail is VSS, not GND -- ngspice treats "gnd" as a
* reserved alias for node 0 (same convention/pitfall already documented
* in script/gen_prm_characterize.py); RING_OSC's own top-level port is
* already named VSS, so this is just kept consistent here.

.param vdd=5.0

vvdd VDD 0 DC 5.0
vvss VSS 0 DC 0

* RSTN drives RING_OSC's ENB (enable) pin directly: 0V (oscillator held
* off) until 10n, then a fast edge up to VDD, held for the rest of the
* run -- per the user's request ("RSTN=0 で 1n で5Vに遷移", later
* extended to "RSTN を 10N まで０に伸ばして").
vrstn RSTN 0 PWL(0n 0 10n 0 10.02n 5.0)

* pin order below is read directly from RING_OSC.extracted's own
* ".SUBCKT RING_OSC ..." line (see gen_ring_osc_tb.py's
* read_ring_osc_pin_order()) -- NOT hand-typed -- because the extracted
* netlist's alphabetical pin order (ENB OUT OUTD VDD VSS) differs from
* the schematic's (OUT OUTD ENB VDD VSS).
xdut RSTN OUT OUTB VDD VSS RING_OSC

.tran 0.02n 3u

* ---- period/frequency measurements ----
* NOTE (fix, 2026-08-31): these MUST be top-level ".measure" directives,
* not "meas" commands inside .control -- a real local ngspice run
* showed the "meas" control-command form fails on PARAM-derived
* expressions ("no such function as 'param=<already-computed-number>'",
* e.g. for period_out/freq_out) even though the prerequisite WHEN
* measurements above them succeed. Top-level ".measure" directives are
* evaluated automatically when the .tran completes and don't have this
* limitation -- this is ngspice's own documented/robust form for
* chained (PARAM=) measurements, confirmed by that real run's own log.
*
* Period is measured between the 1st and 2nd rising crossings after
* RSTN releases (RISE=1/2) -- with ~96-97 inverting stages around each
* loop, the real period is not known ahead of a real run and could
* plausibly be a sizeable fraction of the 3u window, so RISE=1/2 is
* the PRIMARY measurement, guaranteeing at least one period fits.
* RISE=3/4 is also attempted as a secondary, later-cycle cross-check
* (confirms the oscillation has reached a repeatable steady state) --
* if the real period is long enough that a 4th edge doesn't occur
* inside 3u, THIS measurement alone reports "failed" without
* affecting anything else -- rerun with a longer TSTOP in that case.
.measure tran t_out_r1  WHEN v(OUT)=(5.0/2) RISE=1
.measure tran t_out_r2  WHEN v(OUT)=(5.0/2) RISE=2
.measure tran period_out PARAM='t_out_r2-t_out_r1'
.measure tran freq_out   PARAM='1/period_out'

.measure tran t_out_r3  WHEN v(OUT)=(5.0/2) RISE=3
.measure tran t_out_r4  WHEN v(OUT)=(5.0/2) RISE=4
.measure tran period_out_late PARAM='t_out_r4-t_out_r3'
.measure tran freq_out_late   PARAM='1/period_out_late'

.measure tran t_outb_r1 WHEN v(OUTB)=(5.0/2) RISE=1
.measure tran t_outb_r2 WHEN v(OUTB)=(5.0/2) RISE=2
.measure tran period_outb PARAM='t_outb_r2-t_outb_r1'
.measure tran freq_outb   PARAM='1/period_outb'

.measure tran t_outb_r3 WHEN v(OUTB)=(5.0/2) RISE=3
.measure tran t_outb_r4 WHEN v(OUTB)=(5.0/2) RISE=4
.measure tran period_outb_late PARAM='t_outb_r4-t_outb_r3'
.measure tran freq_outb_late   PARAM='1/period_outb_late'

* ---- VDD supply current measurements ----
.measure tran i_vdd_avg AVG i(vvdd) FROM=10.02n TO=3u
.measure tran i_vdd_rms RMS i(vvdd) FROM=10.02n TO=3u

.control
  run

  * fix (2026-08-31, real-run log): the "meas ... MAX abs(i(vvdd))"
  * form errors out ("no such vector as 'abs(i(vvdd))'") -- ngspice's
  * measure trigger wants a plain vector, not an inline function
  * expression. Fix: materialize the abs() as its own vector with "let"
  * (only possible here, after "run", once i(vvdd) actually has data),
  * then measure MAX against that plain vector name.
  let iabs = abs(i(vvdd))
  meas tran i_vdd_peak MAX iabs FROM=0 TO=3u

  print period_out freq_out period_out_late freq_out_late
  print period_outb freq_outb period_outb_late freq_outb_late
  print i_vdd_avg i_vdd_peak i_vdd_rms

  set filetype=ascii
  write tb_ring_osc.raw v(OUT) v(OUTB) v(RSTN) i(vvdd)

  * interactive viewing (ignored harmlessly in -b batch mode without a
  * display; run without -b, or use `ngspice -b tb_ring_osc.spice` and
  * then load tb_ring_osc.raw in any waveform viewer, e.g. `ngspice -r
  * tb_ring_osc.raw` + `plot` at the ngspice prompt, or gaw). OUT/OUTB
  * are on their own plot (direct period/phase comparison between the
  * two rings); RSTN and i(vvdd) are separate so their different
  * voltage/current scales don't distort the OUT/OUTB comparison.
  plot v(out) v(outb)
  plot v(rstn)
  plot i(vvdd)
.endc

.end
