* RING_OSC_extracted_sim_ready.spice -- auto-generated by
* script/gen_ring_osc_tb.py, from:
*   /sessions/dreamy-ecstatic-heisenberg/mnt/TR-1um_Async_I2C/ring_osc/RING_OSC.extracted
* (klayout's real LVS extraction of the RING_OSC layout -- includes
* real per-device extracted AS/AD/PS/PD, already in X-line form, no
* M->X rename needed unlike the earlier schematic-based testbench
* revision). ONE correction applied on top of the verbatim source:
* INV3D's AS<->AD / PS<->PD are swapped on both devices -- the
* extraction had put the antenna-diode-sized diffusion on the
* VDD/GND (supply) side, but the user confirmed from the real layout
* it belongs on the Y (output) side; see fix_inv3d_as_ad_swap()'s own
* docstring and design_notes.md 103.19/103.20 for the full derivation
* and the INV_X1-baseline consistency check that independently
* confirms the swap direction. The master ring_osc/RING_OSC.extracted
* itself is NOT modified -- this correction lives only in this
* simulation copy until the real LVS extraction rule is fixed at the
* source. DO NOT hand-edit further -- regenerate instead.

* Created by KLayout
*** My special header ***

* cell RING_OSC
* pin ENB
* pin OUT
* pin OUTD
* pin VDD
* pin VSS
.SUBCKT RING_OSC ENB OUT OUTD VDD VSS
* cell instance $7 m90 *1 21.6,-120
X$7 VDD VSS FILL2
* cell instance $8 m90 *1 1576.8,-120
X$8 \$I7 \$I54 VDD VSS INV3D
* cell instance $9 m90 *1 1544.4,-120
X$9 \$I54 \$I53 VDD VSS INV3D
* cell instance $10 m90 *1 1512,-120
X$10 \$I53 \$I52 VDD VSS INV3D
* cell instance $11 m90 *1 1479.6,-120
X$11 \$I52 \$I51 VDD VSS INV3D
* cell instance $12 m90 *1 1447.2,-120
X$12 \$I51 \$I50 VDD VSS INV3D
* cell instance $13 m90 *1 1414.8,-120
X$13 \$I50 \$I49 VDD VSS INV3D
* cell instance $14 m90 *1 1382.4,-120
X$14 \$I49 \$I48 VDD VSS INV3D
* cell instance $15 m90 *1 1350,-120
X$15 \$I48 \$I47 VDD VSS INV3D
* cell instance $16 m90 *1 1317.6,-120
X$16 \$I47 \$I46 VDD VSS INV3D
* cell instance $17 m90 *1 1285.2,-120
X$17 \$I46 \$I45 VDD VSS INV3D
* cell instance $18 m90 *1 1252.8,-120
X$18 \$I45 \$I44 VDD VSS INV3D
* cell instance $19 m90 *1 1220.4,-120
X$19 \$I44 \$I43 VDD VSS INV3D
* cell instance $20 m90 *1 1188,-120
X$20 \$I43 \$I42 VDD VSS INV3D
* cell instance $21 m90 *1 1155.6,-120
X$21 \$I42 \$I41 VDD VSS INV3D
* cell instance $22 m90 *1 1123.2,-120
X$22 \$I41 \$I40 VDD VSS INV3D
* cell instance $23 m90 *1 1090.8,-120
X$23 \$I40 \$I39 VDD VSS INV3D
* cell instance $24 m90 *1 1058.4,-120
X$24 \$I39 \$I38 VDD VSS INV3D
* cell instance $25 m90 *1 1026,-120
X$25 \$I38 \$I37 VDD VSS INV3D
* cell instance $26 m90 *1 993.6,-120
X$26 \$I37 \$I36 VDD VSS INV3D
* cell instance $27 m90 *1 961.2,-120
X$27 \$I36 \$I35 VDD VSS INV3D
* cell instance $28 m90 *1 928.8,-120
X$28 \$I35 \$I34 VDD VSS INV3D
* cell instance $29 m90 *1 896.4,-120
X$29 \$I34 \$I33 VDD VSS INV3D
* cell instance $30 m90 *1 864,-120
X$30 \$I33 \$I32 VDD VSS INV3D
* cell instance $31 m90 *1 831.6,-120
X$31 \$I32 \$I31 VDD VSS INV3D
* cell instance $32 m90 *1 799.2,-120
X$32 \$I31 \$I30 VDD VSS INV3D
* cell instance $33 m90 *1 766.8,-120
X$33 \$I30 \$I29 VDD VSS INV3D
* cell instance $34 m90 *1 734.4,-120
X$34 \$I29 \$I28 VDD VSS INV3D
* cell instance $35 m90 *1 702,-120
X$35 \$I28 \$I27 VDD VSS INV3D
* cell instance $36 m90 *1 669.6,-120
X$36 \$I27 \$I26 VDD VSS INV3D
* cell instance $37 m90 *1 637.2,-120
X$37 \$I26 \$I25 VDD VSS INV3D
* cell instance $38 m90 *1 604.8,-120
X$38 \$I25 \$I24 VDD VSS INV3D
* cell instance $39 m90 *1 572.4,-120
X$39 \$I24 \$I23 VDD VSS INV3D
* cell instance $40 m90 *1 540,-120
X$40 \$I23 \$I22 VDD VSS INV3D
* cell instance $41 m90 *1 507.6,-120
X$41 \$I22 \$I21 VDD VSS INV3D
* cell instance $42 m90 *1 475.2,-120
X$42 \$I21 \$I20 VDD VSS INV3D
* cell instance $43 m90 *1 442.8,-120
X$43 \$I20 \$I19 VDD VSS INV3D
* cell instance $44 m90 *1 410.4,-120
X$44 \$I19 \$I18 VDD VSS INV3D
* cell instance $45 m90 *1 378,-120
X$45 \$I18 \$I17 VDD VSS INV3D
* cell instance $46 m90 *1 345.6,-120
X$46 \$I17 \$I16 VDD VSS INV3D
* cell instance $47 m90 *1 313.2,-120
X$47 \$I16 \$I15 VDD VSS INV3D
* cell instance $48 m90 *1 280.8,-120
X$48 \$I15 \$I14 VDD VSS INV3D
* cell instance $49 m90 *1 248.4,-120
X$49 \$I14 \$I13 VDD VSS INV3D
* cell instance $50 m90 *1 216,-120
X$50 \$I13 \$I12 VDD VSS INV3D
* cell instance $51 m90 *1 183.6,-120
X$51 \$I12 \$I11 VDD VSS INV3D
* cell instance $52 m90 *1 151.2,-120
X$52 \$I11 \$I10 VDD VSS INV3D
* cell instance $53 m90 *1 118.8,-120
X$53 \$I10 \$I9 VDD VSS INV3D
* cell instance $54 m90 *1 86.4,-120
X$54 \$I9 \$I8 VDD VSS INV3D
* cell instance $55 m90 *1 54,-120
X$55 \$I8 \$I4 VDD VSS INV3D
* cell instance $56 m90 *1 1609.2,-120
X$56 \$I3 \$I7 VDD VSS INV3D
* cell instance $57 m0 *1 1598.4,4.8
X$57 \$I3 OUTD VDD VSS INV_X1
* cell instance $58 m0 *1 1479.6,4.8
X$58 \$I55 \$I100 VDD VSS INV3D
* cell instance $59 m0 *1 1447.2,4.8
X$59 \$I56 \$I55 VDD VSS INV3D
* cell instance $60 m0 *1 1512,4.8
X$60 \$I100 ENB VDD \$I3 VSS AND2_X1
* cell instance $61 m0 *1 1533.6,4.8
X$61 VDD VSS FILL2
* cell instance $62 m0 *1 1544.4,4.8
X$62 VDD VSS FILL2
* cell instance $63 m0 *1 1555.2,4.8
X$63 VDD VSS FILL2
* cell instance $64 m0 *1 1566,4.8
X$64 VDD VSS FILL2
* cell instance $65 m0 *1 1576.8,4.8
X$65 VDD VSS FILL2
* cell instance $66 m0 *1 1587.6,4.8
X$66 VDD VSS FILL2
* cell instance $67 m0 *1 10.8,4.8
X$67 VDD VSS FILL2
* cell instance $68 m0 *1 21.6,4.8
X$68 \$I4 \$I99 VDD VSS INV3D
* cell instance $69 m0 *1 54,4.8
X$69 \$I99 \$I98 VDD VSS INV3D
* cell instance $70 m0 *1 86.4,4.8
X$70 \$I98 \$I97 VDD VSS INV3D
* cell instance $71 m0 *1 118.8,4.8
X$71 \$I97 \$I96 VDD VSS INV3D
* cell instance $72 m0 *1 151.2,4.8
X$72 \$I96 \$I95 VDD VSS INV3D
* cell instance $73 m0 *1 183.6,4.8
X$73 \$I95 \$I94 VDD VSS INV3D
* cell instance $74 m0 *1 216,4.8
X$74 \$I94 \$I93 VDD VSS INV3D
* cell instance $75 m0 *1 248.4,4.8
X$75 \$I93 \$I92 VDD VSS INV3D
* cell instance $76 m0 *1 280.8,4.8
X$76 \$I92 \$I91 VDD VSS INV3D
* cell instance $77 m0 *1 313.2,4.8
X$77 \$I91 \$I90 VDD VSS INV3D
* cell instance $78 m0 *1 345.6,4.8
X$78 \$I90 \$I89 VDD VSS INV3D
* cell instance $79 m0 *1 378,4.8
X$79 \$I89 \$I88 VDD VSS INV3D
* cell instance $80 m0 *1 410.4,4.8
X$80 \$I88 \$I87 VDD VSS INV3D
* cell instance $81 m0 *1 442.8,4.8
X$81 \$I87 \$I86 VDD VSS INV3D
* cell instance $82 m0 *1 475.2,4.8
X$82 \$I86 \$I85 VDD VSS INV3D
* cell instance $83 m0 *1 507.6,4.8
X$83 \$I85 \$I84 VDD VSS INV3D
* cell instance $84 m0 *1 540,4.8
X$84 \$I84 \$I83 VDD VSS INV3D
* cell instance $85 m0 *1 572.4,4.8
X$85 \$I83 \$I82 VDD VSS INV3D
* cell instance $86 m0 *1 604.8,4.8
X$86 \$I82 \$I81 VDD VSS INV3D
* cell instance $87 m0 *1 637.2,4.8
X$87 \$I81 \$I80 VDD VSS INV3D
* cell instance $88 m0 *1 669.6,4.8
X$88 \$I80 \$I79 VDD VSS INV3D
* cell instance $89 m0 *1 702,4.8
X$89 \$I79 \$I78 VDD VSS INV3D
* cell instance $90 m0 *1 734.4,4.8
X$90 \$I78 \$I77 VDD VSS INV3D
* cell instance $91 m0 *1 766.8,4.8
X$91 \$I77 \$I76 VDD VSS INV3D
* cell instance $92 m0 *1 799.2,4.8
X$92 \$I76 \$I75 VDD VSS INV3D
* cell instance $93 m0 *1 831.6,4.8
X$93 \$I75 \$I74 VDD VSS INV3D
* cell instance $94 m0 *1 864,4.8
X$94 \$I74 \$I73 VDD VSS INV3D
* cell instance $95 m0 *1 896.4,4.8
X$95 \$I73 \$I72 VDD VSS INV3D
* cell instance $96 m0 *1 928.8,4.8
X$96 \$I72 \$I71 VDD VSS INV3D
* cell instance $97 m0 *1 961.2,4.8
X$97 \$I71 \$I70 VDD VSS INV3D
* cell instance $98 m0 *1 993.6,4.8
X$98 \$I70 \$I69 VDD VSS INV3D
* cell instance $99 m0 *1 1026,4.8
X$99 \$I69 \$I68 VDD VSS INV3D
* cell instance $100 m0 *1 1058.4,4.8
X$100 \$I68 \$I67 VDD VSS INV3D
* cell instance $101 m0 *1 1090.8,4.8
X$101 \$I67 \$I66 VDD VSS INV3D
* cell instance $102 m0 *1 1123.2,4.8
X$102 \$I66 \$I65 VDD VSS INV3D
* cell instance $103 m0 *1 1155.6,4.8
X$103 \$I65 \$I64 VDD VSS INV3D
* cell instance $104 m0 *1 1188,4.8
X$104 \$I64 \$I63 VDD VSS INV3D
* cell instance $105 m0 *1 1220.4,4.8
X$105 \$I63 \$I62 VDD VSS INV3D
* cell instance $106 m0 *1 1252.8,4.8
X$106 \$I62 \$I61 VDD VSS INV3D
* cell instance $107 m0 *1 1285.2,4.8
X$107 \$I61 \$I60 VDD VSS INV3D
* cell instance $108 m0 *1 1317.6,4.8
X$108 \$I60 \$I59 VDD VSS INV3D
* cell instance $109 m0 *1 1350,4.8
X$109 \$I59 \$I58 VDD VSS INV3D
* cell instance $110 m0 *1 1382.4,4.8
X$110 \$I58 \$I57 VDD VSS INV3D
* cell instance $111 m0 *1 1414.8,4.8
X$111 \$I57 \$I56 VDD VSS INV3D
* cell instance $112 r180 *1 21.6,124.8
X$112 VDD VSS FILL2
* cell instance $162 r0 *1 1598.4,0
X$162 \$I5 OUT VDD VSS INV_X1
* cell instance $165 r0 *1 1512,0
X$165 \$I194 ENB VDD \$I5 VSS AND2_X1
* cell instance $166 r0 *1 1533.6,0
X$166 VDD VSS FILL2
* cell instance $167 r0 *1 1544.4,0
X$167 VDD VSS FILL2
* cell instance $168 r0 *1 1555.2,0
X$168 VDD VSS FILL2
* cell instance $169 r0 *1 1566,0
X$169 VDD VSS FILL2
* cell instance $170 r0 *1 1576.8,0
X$170 VDD VSS FILL2
* cell instance $171 r0 *1 1587.6,0
X$171 VDD VSS FILL2
* cell instance $172 r0 *1 10.8,0
X$172 VDD VSS FILL2
* cell instance $217 r180 *1 1609.2,124.8
X$217 \$I5 \$I101 VDD VSS INV_X1
* cell instance $218 r180 *1 1587.6,124.8
X$218 VDD VSS FILL2
* cell instance $219 r180 *1 1598.4,124.8
X$219 VDD VSS FILL2
* cell instance $220 r180 *1 1576.8,124.8
X$220 \$I101 \$I148 VDD VSS INV_X1
* cell instance $221 r180 *1 1555.2,124.8
X$221 VDD VSS FILL2
* cell instance $222 r180 *1 1566,124.8
X$222 VDD VSS FILL2
* cell instance $223 r180 *1 1544.4,124.8
X$223 \$I148 \$I147 VDD VSS INV_X1
* cell instance $224 r180 *1 1522.8,124.8
X$224 VDD VSS FILL2
* cell instance $225 r180 *1 1533.6,124.8
X$225 VDD VSS FILL2
* cell instance $226 r180 *1 1512,124.8
X$226 \$I147 \$I146 VDD VSS INV_X1
* cell instance $227 r180 *1 1490.4,124.8
X$227 VDD VSS FILL2
* cell instance $228 r180 *1 1501.2,124.8
X$228 VDD VSS FILL2
* cell instance $229 r180 *1 1479.6,124.8
X$229 \$I146 \$I145 VDD VSS INV_X1
* cell instance $230 r180 *1 1458,124.8
X$230 VDD VSS FILL2
* cell instance $231 r180 *1 1468.8,124.8
X$231 VDD VSS FILL2
* cell instance $232 r180 *1 1447.2,124.8
X$232 \$I145 \$I144 VDD VSS INV_X1
* cell instance $233 r180 *1 1425.6,124.8
X$233 VDD VSS FILL2
* cell instance $234 r180 *1 1436.4,124.8
X$234 VDD VSS FILL2
* cell instance $235 r180 *1 1414.8,124.8
X$235 \$I144 \$I143 VDD VSS INV_X1
* cell instance $236 r180 *1 1393.2,124.8
X$236 VDD VSS FILL2
* cell instance $237 r180 *1 1404,124.8
X$237 VDD VSS FILL2
* cell instance $238 r180 *1 1382.4,124.8
X$238 \$I143 \$I142 VDD VSS INV_X1
* cell instance $239 r180 *1 1360.8,124.8
X$239 VDD VSS FILL2
* cell instance $240 r180 *1 1371.6,124.8
X$240 VDD VSS FILL2
* cell instance $241 r180 *1 1350,124.8
X$241 \$I142 \$I141 VDD VSS INV_X1
* cell instance $242 r180 *1 1328.4,124.8
X$242 VDD VSS FILL2
* cell instance $243 r180 *1 1339.2,124.8
X$243 VDD VSS FILL2
* cell instance $244 r180 *1 1317.6,124.8
X$244 \$I141 \$I140 VDD VSS INV_X1
* cell instance $245 r180 *1 1296,124.8
X$245 VDD VSS FILL2
* cell instance $246 r180 *1 1306.8,124.8
X$246 VDD VSS FILL2
* cell instance $247 r180 *1 1285.2,124.8
X$247 \$I140 \$I139 VDD VSS INV_X1
* cell instance $248 r180 *1 1263.6,124.8
X$248 VDD VSS FILL2
* cell instance $249 r180 *1 1274.4,124.8
X$249 VDD VSS FILL2
* cell instance $250 r180 *1 1252.8,124.8
X$250 \$I139 \$I138 VDD VSS INV_X1
* cell instance $251 r180 *1 1231.2,124.8
X$251 VDD VSS FILL2
* cell instance $252 r180 *1 1242,124.8
X$252 VDD VSS FILL2
* cell instance $253 r180 *1 1220.4,124.8
X$253 \$I138 \$I137 VDD VSS INV_X1
* cell instance $254 r180 *1 1198.8,124.8
X$254 VDD VSS FILL2
* cell instance $255 r180 *1 1209.6,124.8
X$255 VDD VSS FILL2
* cell instance $256 r180 *1 1188,124.8
X$256 \$I137 \$I136 VDD VSS INV_X1
* cell instance $257 r180 *1 1166.4,124.8
X$257 VDD VSS FILL2
* cell instance $258 r180 *1 1177.2,124.8
X$258 VDD VSS FILL2
* cell instance $259 r180 *1 1155.6,124.8
X$259 \$I136 \$I135 VDD VSS INV_X1
* cell instance $260 r180 *1 1134,124.8
X$260 VDD VSS FILL2
* cell instance $261 r180 *1 1144.8,124.8
X$261 VDD VSS FILL2
* cell instance $262 r180 *1 1123.2,124.8
X$262 \$I135 \$I134 VDD VSS INV_X1
* cell instance $263 r180 *1 1101.6,124.8
X$263 VDD VSS FILL2
* cell instance $264 r180 *1 1112.4,124.8
X$264 VDD VSS FILL2
* cell instance $265 r180 *1 1090.8,124.8
X$265 \$I134 \$I133 VDD VSS INV_X1
* cell instance $266 r180 *1 1069.2,124.8
X$266 VDD VSS FILL2
* cell instance $267 r180 *1 1080,124.8
X$267 VDD VSS FILL2
* cell instance $268 r180 *1 1058.4,124.8
X$268 \$I133 \$I132 VDD VSS INV_X1
* cell instance $269 r180 *1 1036.8,124.8
X$269 VDD VSS FILL2
* cell instance $270 r180 *1 1047.6,124.8
X$270 VDD VSS FILL2
* cell instance $271 r180 *1 1026,124.8
X$271 \$I132 \$I131 VDD VSS INV_X1
* cell instance $272 r180 *1 1004.4,124.8
X$272 VDD VSS FILL2
* cell instance $273 r180 *1 1015.2,124.8
X$273 VDD VSS FILL2
* cell instance $274 r180 *1 993.6,124.8
X$274 \$I131 \$I130 VDD VSS INV_X1
* cell instance $275 r180 *1 972,124.8
X$275 VDD VSS FILL2
* cell instance $276 r180 *1 982.8,124.8
X$276 VDD VSS FILL2
* cell instance $277 r180 *1 961.2,124.8
X$277 \$I130 \$I129 VDD VSS INV_X1
* cell instance $278 r180 *1 939.6,124.8
X$278 VDD VSS FILL2
* cell instance $279 r180 *1 950.4,124.8
X$279 VDD VSS FILL2
* cell instance $280 r180 *1 928.8,124.8
X$280 \$I129 \$I128 VDD VSS INV_X1
* cell instance $281 r180 *1 907.2,124.8
X$281 VDD VSS FILL2
* cell instance $282 r180 *1 918,124.8
X$282 VDD VSS FILL2
* cell instance $283 r180 *1 896.4,124.8
X$283 \$I128 \$I127 VDD VSS INV_X1
* cell instance $284 r180 *1 874.8,124.8
X$284 VDD VSS FILL2
* cell instance $285 r180 *1 885.6,124.8
X$285 VDD VSS FILL2
* cell instance $286 r180 *1 864,124.8
X$286 \$I127 \$I126 VDD VSS INV_X1
* cell instance $287 r180 *1 842.4,124.8
X$287 VDD VSS FILL2
* cell instance $288 r180 *1 853.2,124.8
X$288 VDD VSS FILL2
* cell instance $289 r180 *1 831.6,124.8
X$289 \$I126 \$I125 VDD VSS INV_X1
* cell instance $290 r180 *1 810,124.8
X$290 VDD VSS FILL2
* cell instance $291 r180 *1 820.8,124.8
X$291 VDD VSS FILL2
* cell instance $292 r180 *1 799.2,124.8
X$292 \$I125 \$I124 VDD VSS INV_X1
* cell instance $293 r180 *1 777.6,124.8
X$293 VDD VSS FILL2
* cell instance $294 r180 *1 788.4,124.8
X$294 VDD VSS FILL2
* cell instance $295 r180 *1 766.8,124.8
X$295 \$I124 \$I123 VDD VSS INV_X1
* cell instance $296 r180 *1 745.2,124.8
X$296 VDD VSS FILL2
* cell instance $297 r180 *1 756,124.8
X$297 VDD VSS FILL2
* cell instance $298 r180 *1 734.4,124.8
X$298 \$I123 \$I122 VDD VSS INV_X1
* cell instance $299 r180 *1 712.8,124.8
X$299 VDD VSS FILL2
* cell instance $300 r180 *1 723.6,124.8
X$300 VDD VSS FILL2
* cell instance $301 r180 *1 702,124.8
X$301 \$I122 \$I121 VDD VSS INV_X1
* cell instance $302 r180 *1 680.4,124.8
X$302 VDD VSS FILL2
* cell instance $303 r180 *1 691.2,124.8
X$303 VDD VSS FILL2
* cell instance $304 r180 *1 669.6,124.8
X$304 \$I121 \$I120 VDD VSS INV_X1
* cell instance $305 r180 *1 648,124.8
X$305 VDD VSS FILL2
* cell instance $306 r180 *1 658.8,124.8
X$306 VDD VSS FILL2
* cell instance $307 r180 *1 637.2,124.8
X$307 \$I120 \$I119 VDD VSS INV_X1
* cell instance $308 r180 *1 615.6,124.8
X$308 VDD VSS FILL2
* cell instance $309 r180 *1 626.4,124.8
X$309 VDD VSS FILL2
* cell instance $310 r180 *1 604.8,124.8
X$310 \$I119 \$I118 VDD VSS INV_X1
* cell instance $311 r180 *1 583.2,124.8
X$311 VDD VSS FILL2
* cell instance $312 r180 *1 594,124.8
X$312 VDD VSS FILL2
* cell instance $313 r180 *1 572.4,124.8
X$313 \$I118 \$I117 VDD VSS INV_X1
* cell instance $314 r180 *1 550.8,124.8
X$314 VDD VSS FILL2
* cell instance $315 r180 *1 561.6,124.8
X$315 VDD VSS FILL2
* cell instance $316 r180 *1 540,124.8
X$316 \$I117 \$I116 VDD VSS INV_X1
* cell instance $317 r180 *1 518.4,124.8
X$317 VDD VSS FILL2
* cell instance $318 r180 *1 529.2,124.8
X$318 VDD VSS FILL2
* cell instance $319 r180 *1 507.6,124.8
X$319 \$I116 \$I115 VDD VSS INV_X1
* cell instance $320 r180 *1 486,124.8
X$320 VDD VSS FILL2
* cell instance $321 r180 *1 496.8,124.8
X$321 VDD VSS FILL2
* cell instance $322 r180 *1 475.2,124.8
X$322 \$I115 \$I114 VDD VSS INV_X1
* cell instance $323 r180 *1 453.6,124.8
X$323 VDD VSS FILL2
* cell instance $324 r180 *1 464.4,124.8
X$324 VDD VSS FILL2
* cell instance $325 r180 *1 442.8,124.8
X$325 \$I114 \$I113 VDD VSS INV_X1
* cell instance $326 r180 *1 421.2,124.8
X$326 VDD VSS FILL2
* cell instance $327 r180 *1 432,124.8
X$327 VDD VSS FILL2
* cell instance $328 r180 *1 410.4,124.8
X$328 \$I113 \$I112 VDD VSS INV_X1
* cell instance $329 r180 *1 388.8,124.8
X$329 VDD VSS FILL2
* cell instance $330 r180 *1 399.6,124.8
X$330 VDD VSS FILL2
* cell instance $331 r180 *1 378,124.8
X$331 \$I112 \$I111 VDD VSS INV_X1
* cell instance $332 r180 *1 356.4,124.8
X$332 VDD VSS FILL2
* cell instance $333 r180 *1 367.2,124.8
X$333 VDD VSS FILL2
* cell instance $334 r180 *1 345.6,124.8
X$334 \$I111 \$I110 VDD VSS INV_X1
* cell instance $335 r180 *1 324,124.8
X$335 VDD VSS FILL2
* cell instance $336 r180 *1 334.8,124.8
X$336 VDD VSS FILL2
* cell instance $337 r180 *1 313.2,124.8
X$337 \$I110 \$I109 VDD VSS INV_X1
* cell instance $338 r180 *1 291.6,124.8
X$338 VDD VSS FILL2
* cell instance $339 r180 *1 302.4,124.8
X$339 VDD VSS FILL2
* cell instance $340 r180 *1 280.8,124.8
X$340 \$I109 \$I108 VDD VSS INV_X1
* cell instance $341 r180 *1 259.2,124.8
X$341 VDD VSS FILL2
* cell instance $342 r180 *1 270,124.8
X$342 VDD VSS FILL2
* cell instance $343 r180 *1 248.4,124.8
X$343 \$I108 \$I107 VDD VSS INV_X1
* cell instance $344 r180 *1 226.8,124.8
X$344 VDD VSS FILL2
* cell instance $345 r180 *1 237.6,124.8
X$345 VDD VSS FILL2
* cell instance $346 r180 *1 216,124.8
X$346 \$I107 \$I106 VDD VSS INV_X1
* cell instance $347 r180 *1 194.4,124.8
X$347 VDD VSS FILL2
* cell instance $348 r180 *1 205.2,124.8
X$348 VDD VSS FILL2
* cell instance $349 r180 *1 183.6,124.8
X$349 \$I106 \$I105 VDD VSS INV_X1
* cell instance $350 r180 *1 162,124.8
X$350 VDD VSS FILL2
* cell instance $351 r180 *1 172.8,124.8
X$351 VDD VSS FILL2
* cell instance $352 r180 *1 151.2,124.8
X$352 \$I105 \$I104 VDD VSS INV_X1
* cell instance $353 r180 *1 129.6,124.8
X$353 VDD VSS FILL2
* cell instance $354 r180 *1 140.4,124.8
X$354 VDD VSS FILL2
* cell instance $355 r180 *1 118.8,124.8
X$355 \$I104 \$I103 VDD VSS INV_X1
* cell instance $356 r180 *1 97.2,124.8
X$356 VDD VSS FILL2
* cell instance $357 r180 *1 108,124.8
X$357 VDD VSS FILL2
* cell instance $358 r180 *1 86.4,124.8
X$358 \$I103 \$I102 VDD VSS INV_X1
* cell instance $359 r180 *1 64.8,124.8
X$359 VDD VSS FILL2
* cell instance $360 r180 *1 75.6,124.8
X$360 VDD VSS FILL2
* cell instance $361 r180 *1 54,124.8
X$361 \$I102 \$I6 VDD VSS INV_X1
* cell instance $362 r180 *1 32.4,124.8
X$362 VDD VSS FILL2
* cell instance $363 r180 *1 43.2,124.8
X$363 VDD VSS FILL2
* cell instance $364 r0 *1 1479.6,0
X$364 \$I149 \$I194 VDD VSS INV_X1
* cell instance $365 r0 *1 1501.2,0
X$365 VDD VSS FILL2
* cell instance $366 r0 *1 1490.4,0
X$366 VDD VSS FILL2
* cell instance $367 r0 *1 1447.2,0
X$367 \$I150 \$I149 VDD VSS INV_X1
* cell instance $368 r0 *1 1468.8,0
X$368 VDD VSS FILL2
* cell instance $369 r0 *1 1458,0
X$369 VDD VSS FILL2
* cell instance $370 r0 *1 21.6,0
X$370 \$I6 \$I193 VDD VSS INV_X1
* cell instance $371 r0 *1 43.2,0
X$371 VDD VSS FILL2
* cell instance $372 r0 *1 32.4,0
X$372 VDD VSS FILL2
* cell instance $373 r0 *1 54,0
X$373 \$I193 \$I192 VDD VSS INV_X1
* cell instance $374 r0 *1 75.6,0
X$374 VDD VSS FILL2
* cell instance $375 r0 *1 64.8,0
X$375 VDD VSS FILL2
* cell instance $376 r0 *1 86.4,0
X$376 \$I192 \$I191 VDD VSS INV_X1
* cell instance $377 r0 *1 108,0
X$377 VDD VSS FILL2
* cell instance $378 r0 *1 97.2,0
X$378 VDD VSS FILL2
* cell instance $379 r0 *1 118.8,0
X$379 \$I191 \$I190 VDD VSS INV_X1
* cell instance $380 r0 *1 140.4,0
X$380 VDD VSS FILL2
* cell instance $381 r0 *1 129.6,0
X$381 VDD VSS FILL2
* cell instance $382 r0 *1 151.2,0
X$382 \$I190 \$I189 VDD VSS INV_X1
* cell instance $383 r0 *1 172.8,0
X$383 VDD VSS FILL2
* cell instance $384 r0 *1 162,0
X$384 VDD VSS FILL2
* cell instance $385 r0 *1 183.6,0
X$385 \$I189 \$I188 VDD VSS INV_X1
* cell instance $386 r0 *1 205.2,0
X$386 VDD VSS FILL2
* cell instance $387 r0 *1 194.4,0
X$387 VDD VSS FILL2
* cell instance $388 r0 *1 216,0
X$388 \$I188 \$I187 VDD VSS INV_X1
* cell instance $389 r0 *1 237.6,0
X$389 VDD VSS FILL2
* cell instance $390 r0 *1 226.8,0
X$390 VDD VSS FILL2
* cell instance $391 r0 *1 248.4,0
X$391 \$I187 \$I186 VDD VSS INV_X1
* cell instance $392 r0 *1 270,0
X$392 VDD VSS FILL2
* cell instance $393 r0 *1 259.2,0
X$393 VDD VSS FILL2
* cell instance $394 r0 *1 280.8,0
X$394 \$I186 \$I185 VDD VSS INV_X1
* cell instance $395 r0 *1 302.4,0
X$395 VDD VSS FILL2
* cell instance $396 r0 *1 291.6,0
X$396 VDD VSS FILL2
* cell instance $397 r0 *1 313.2,0
X$397 \$I185 \$I184 VDD VSS INV_X1
* cell instance $398 r0 *1 334.8,0
X$398 VDD VSS FILL2
* cell instance $399 r0 *1 324,0
X$399 VDD VSS FILL2
* cell instance $400 r0 *1 345.6,0
X$400 \$I184 \$I183 VDD VSS INV_X1
* cell instance $401 r0 *1 367.2,0
X$401 VDD VSS FILL2
* cell instance $402 r0 *1 356.4,0
X$402 VDD VSS FILL2
* cell instance $403 r0 *1 378,0
X$403 \$I183 \$I182 VDD VSS INV_X1
* cell instance $404 r0 *1 399.6,0
X$404 VDD VSS FILL2
* cell instance $405 r0 *1 388.8,0
X$405 VDD VSS FILL2
* cell instance $406 r0 *1 410.4,0
X$406 \$I182 \$I181 VDD VSS INV_X1
* cell instance $407 r0 *1 432,0
X$407 VDD VSS FILL2
* cell instance $408 r0 *1 421.2,0
X$408 VDD VSS FILL2
* cell instance $409 r0 *1 442.8,0
X$409 \$I181 \$I180 VDD VSS INV_X1
* cell instance $410 r0 *1 464.4,0
X$410 VDD VSS FILL2
* cell instance $411 r0 *1 453.6,0
X$411 VDD VSS FILL2
* cell instance $412 r0 *1 475.2,0
X$412 \$I180 \$I179 VDD VSS INV_X1
* cell instance $413 r0 *1 496.8,0
X$413 VDD VSS FILL2
* cell instance $414 r0 *1 486,0
X$414 VDD VSS FILL2
* cell instance $415 r0 *1 507.6,0
X$415 \$I179 \$I178 VDD VSS INV_X1
* cell instance $416 r0 *1 529.2,0
X$416 VDD VSS FILL2
* cell instance $417 r0 *1 518.4,0
X$417 VDD VSS FILL2
* cell instance $418 r0 *1 540,0
X$418 \$I178 \$I177 VDD VSS INV_X1
* cell instance $419 r0 *1 561.6,0
X$419 VDD VSS FILL2
* cell instance $420 r0 *1 550.8,0
X$420 VDD VSS FILL2
* cell instance $421 r0 *1 572.4,0
X$421 \$I177 \$I176 VDD VSS INV_X1
* cell instance $422 r0 *1 594,0
X$422 VDD VSS FILL2
* cell instance $423 r0 *1 583.2,0
X$423 VDD VSS FILL2
* cell instance $424 r0 *1 604.8,0
X$424 \$I176 \$I175 VDD VSS INV_X1
* cell instance $425 r0 *1 626.4,0
X$425 VDD VSS FILL2
* cell instance $426 r0 *1 615.6,0
X$426 VDD VSS FILL2
* cell instance $427 r0 *1 637.2,0
X$427 \$I175 \$I174 VDD VSS INV_X1
* cell instance $428 r0 *1 658.8,0
X$428 VDD VSS FILL2
* cell instance $429 r0 *1 648,0
X$429 VDD VSS FILL2
* cell instance $430 r0 *1 669.6,0
X$430 \$I174 \$I173 VDD VSS INV_X1
* cell instance $431 r0 *1 691.2,0
X$431 VDD VSS FILL2
* cell instance $432 r0 *1 680.4,0
X$432 VDD VSS FILL2
* cell instance $433 r0 *1 702,0
X$433 \$I173 \$I172 VDD VSS INV_X1
* cell instance $434 r0 *1 723.6,0
X$434 VDD VSS FILL2
* cell instance $435 r0 *1 712.8,0
X$435 VDD VSS FILL2
* cell instance $436 r0 *1 734.4,0
X$436 \$I172 \$I171 VDD VSS INV_X1
* cell instance $437 r0 *1 756,0
X$437 VDD VSS FILL2
* cell instance $438 r0 *1 745.2,0
X$438 VDD VSS FILL2
* cell instance $439 r0 *1 766.8,0
X$439 \$I171 \$I170 VDD VSS INV_X1
* cell instance $440 r0 *1 788.4,0
X$440 VDD VSS FILL2
* cell instance $441 r0 *1 777.6,0
X$441 VDD VSS FILL2
* cell instance $442 r0 *1 799.2,0
X$442 \$I170 \$I169 VDD VSS INV_X1
* cell instance $443 r0 *1 820.8,0
X$443 VDD VSS FILL2
* cell instance $444 r0 *1 810,0
X$444 VDD VSS FILL2
* cell instance $445 r0 *1 831.6,0
X$445 \$I169 \$I168 VDD VSS INV_X1
* cell instance $446 r0 *1 853.2,0
X$446 VDD VSS FILL2
* cell instance $447 r0 *1 842.4,0
X$447 VDD VSS FILL2
* cell instance $448 r0 *1 864,0
X$448 \$I168 \$I167 VDD VSS INV_X1
* cell instance $449 r0 *1 885.6,0
X$449 VDD VSS FILL2
* cell instance $450 r0 *1 874.8,0
X$450 VDD VSS FILL2
* cell instance $451 r0 *1 896.4,0
X$451 \$I167 \$I166 VDD VSS INV_X1
* cell instance $452 r0 *1 918,0
X$452 VDD VSS FILL2
* cell instance $453 r0 *1 907.2,0
X$453 VDD VSS FILL2
* cell instance $454 r0 *1 928.8,0
X$454 \$I166 \$I165 VDD VSS INV_X1
* cell instance $455 r0 *1 950.4,0
X$455 VDD VSS FILL2
* cell instance $456 r0 *1 939.6,0
X$456 VDD VSS FILL2
* cell instance $457 r0 *1 961.2,0
X$457 \$I165 \$I164 VDD VSS INV_X1
* cell instance $458 r0 *1 982.8,0
X$458 VDD VSS FILL2
* cell instance $459 r0 *1 972,0
X$459 VDD VSS FILL2
* cell instance $460 r0 *1 993.6,0
X$460 \$I164 \$I163 VDD VSS INV_X1
* cell instance $461 r0 *1 1015.2,0
X$461 VDD VSS FILL2
* cell instance $462 r0 *1 1004.4,0
X$462 VDD VSS FILL2
* cell instance $463 r0 *1 1026,0
X$463 \$I163 \$I162 VDD VSS INV_X1
* cell instance $464 r0 *1 1047.6,0
X$464 VDD VSS FILL2
* cell instance $465 r0 *1 1036.8,0
X$465 VDD VSS FILL2
* cell instance $466 r0 *1 1058.4,0
X$466 \$I162 \$I161 VDD VSS INV_X1
* cell instance $467 r0 *1 1080,0
X$467 VDD VSS FILL2
* cell instance $468 r0 *1 1069.2,0
X$468 VDD VSS FILL2
* cell instance $469 r0 *1 1090.8,0
X$469 \$I161 \$I160 VDD VSS INV_X1
* cell instance $470 r0 *1 1112.4,0
X$470 VDD VSS FILL2
* cell instance $471 r0 *1 1101.6,0
X$471 VDD VSS FILL2
* cell instance $472 r0 *1 1123.2,0
X$472 \$I160 \$I159 VDD VSS INV_X1
* cell instance $473 r0 *1 1144.8,0
X$473 VDD VSS FILL2
* cell instance $474 r0 *1 1134,0
X$474 VDD VSS FILL2
* cell instance $475 r0 *1 1155.6,0
X$475 \$I159 \$I158 VDD VSS INV_X1
* cell instance $476 r0 *1 1177.2,0
X$476 VDD VSS FILL2
* cell instance $477 r0 *1 1166.4,0
X$477 VDD VSS FILL2
* cell instance $478 r0 *1 1188,0
X$478 \$I158 \$I157 VDD VSS INV_X1
* cell instance $479 r0 *1 1209.6,0
X$479 VDD VSS FILL2
* cell instance $480 r0 *1 1198.8,0
X$480 VDD VSS FILL2
* cell instance $481 r0 *1 1220.4,0
X$481 \$I157 \$I156 VDD VSS INV_X1
* cell instance $482 r0 *1 1242,0
X$482 VDD VSS FILL2
* cell instance $483 r0 *1 1231.2,0
X$483 VDD VSS FILL2
* cell instance $484 r0 *1 1252.8,0
X$484 \$I156 \$I155 VDD VSS INV_X1
* cell instance $485 r0 *1 1274.4,0
X$485 VDD VSS FILL2
* cell instance $486 r0 *1 1263.6,0
X$486 VDD VSS FILL2
* cell instance $487 r0 *1 1285.2,0
X$487 \$I155 \$I154 VDD VSS INV_X1
* cell instance $488 r0 *1 1306.8,0
X$488 VDD VSS FILL2
* cell instance $489 r0 *1 1296,0
X$489 VDD VSS FILL2
* cell instance $490 r0 *1 1317.6,0
X$490 \$I154 \$I153 VDD VSS INV_X1
* cell instance $491 r0 *1 1339.2,0
X$491 VDD VSS FILL2
* cell instance $492 r0 *1 1328.4,0
X$492 VDD VSS FILL2
* cell instance $493 r0 *1 1350,0
X$493 \$I153 \$I152 VDD VSS INV_X1
* cell instance $494 r0 *1 1371.6,0
X$494 VDD VSS FILL2
* cell instance $495 r0 *1 1360.8,0
X$495 VDD VSS FILL2
* cell instance $496 r0 *1 1382.4,0
X$496 \$I152 \$I151 VDD VSS INV_X1
* cell instance $497 r0 *1 1404,0
X$497 VDD VSS FILL2
* cell instance $498 r0 *1 1393.2,0
X$498 VDD VSS FILL2
* cell instance $499 r0 *1 1414.8,0
X$499 \$I151 \$I150 VDD VSS INV_X1
* cell instance $500 r0 *1 1436.4,0
X$500 VDD VSS FILL2
* cell instance $501 r0 *1 1425.6,0
X$501 VDD VSS FILL2
.ENDS RING_OSC

* cell INV3D
* pin A
* pin Y
* pin vdd
* pin gnd
.SUBCKT INV3D A Y vdd gnd
* device instance $1 r0 *1 4,53.2 PMOS
XM$1 Y A vdd vdd PMOS L=1u W=10.2u AS=28.56p AD=539.48p PS=26u PD=96.2u
* device instance $2 r0 *1 5.4,8.2 NMOS
XM$2 gnd A Y gnd NMOS L=1u W=3.4u AS=306.89p AD=9.52p PS=77.2u PD=12.4u
.ENDS INV3D

* cell INV_X1
* pin A
* pin Y
* pin vdd
* pin gnd
.SUBCKT INV_X1 A Y vdd gnd
* device instance $1 r0 *1 4,53.2 PMOS
XM$1 vdd A Y vdd PMOS L=1u W=10.2u AS=28.56p AD=28.56p PS=26u PD=26u
* device instance $2 r0 *1 5.4,8.2 NMOS
XM$2 gnd A Y gnd NMOS L=1u W=3.4u AS=9.52p AD=9.52p PS=12.4u PD=12.4u
.ENDS INV_X1

* cell AND2_X1
* pin A
* pin B
* pin vdd
* pin Y
* pin gnd
.SUBCKT AND2_X1 A B vdd Y gnd
* device instance $1 r0 *1 4,53.2 PMOS
XM$1 vdd A \$1 vdd PMOS L=1u W=10.2u AS=28.56p AD=15.3p PS=26u PD=13.2u
* device instance $2 r0 *1 8,53.2 PMOS
XM$2 \$1 B vdd vdd PMOS L=1u W=10.2u AS=15.3p AD=15.3p PS=13.2u PD=13.2u
* device instance $3 r0 *1 12,53.2 PMOS
XM$3 vdd \$1 Y vdd PMOS L=1u W=10.2u AS=15.3p AD=28.56p PS=13.2u PD=26u
* device instance $4 r0 *1 8.6,17.9 NMOS
XM$4 gnd A \$7 gnd NMOS L=1u W=3.4u AS=9.52p AD=2.04p PS=12.4u PD=4.6u
* device instance $5 r0 *1 10.8,17.9 NMOS
XM$5 \$7 B \$1 gnd NMOS L=1u W=3.4u AS=2.04p AD=9.52p PS=4.6u PD=12.4u
* device instance $6 r0 *1 16.2,9.4 NMOS
XM$6 gnd \$1 Y gnd NMOS L=1u W=3.4u AS=35.36p AD=9.52p PS=27.6u PD=12.4u
.ENDS AND2_X1

* cell FILL2
* pin vdd
* pin gnd
.SUBCKT FILL2 vdd gnd
* device instance $1 r0 *1 5.4,47.7 PMOS
XM$1 vdd gnd vdd vdd PMOS L=3.2u W=21.2u AS=59.36p AD=59.36p PS=48u PD=48u
* device instance $2 r0 *1 5.4,13.05 NMOS
XM$2 gnd vdd gnd gnd NMOS L=3.2u W=13.1u AS=36.68p AD=36.68p PS=31.8u PD=31.8u
.ENDS FILL2
