** tr_1um_i2c_slave_async_v9_lvs.spice -- chip-level LVS reference netlist (v9)
** Generated by script/gen_lvs_spice_top_v9.py from:
**   1) schematic/i2c_slave_async_nrow_fm_v9.spice (core, LVS-clean per
**      design_notes.md 77.47 -- "Congratulations! Netlists match.")
**   2) simulations/OSS_FRAME_GIO.spice (GIO pad-ring frame, transistor
**      level, from its own xschem schematic)
**   3) schematic/gio_connections.json (GIO<->core connection map,
**      derived + cross-verified in design_notes.md 78.1/78.4)
** x1 = OSS_FRAME_GIO, x2 = i2c_slave_async_nrow_fm, matching the
** instance naming already used in the (now-stale, pre-v9)
** src/tr_1um_i2c_slave_async.cir. Nets prefixed NC_ are genuinely
** unconnected on both sides (spare pads P9/P10/P11-in/OUT2/OUT7/OUT9/
** OUT10/OUT15, and core's tx_data[1]/rx_valid/addr_match/rw/busy --
** none of these are wired to any GIO pad in this design, confirmed by
** gio_connections.json's own "core_outputs_not_connected_to_any_pad"
** and per-terminal "unconnected" notes) -- each gets its own unique
** floating net name rather than being tied together, so LVS sees them
** as independently floating, matching the real chip.
**
** TOP-LEVEL PIN FIX (this revision): the top subckt now declares its
** 16 real bond-pad ports explicitly (P1-P7, VSS, P9-P15, VDD -- P8
** does not exist in this frame). The previous revision had a
** port-less ".subckt tr_1um_i2c_slave_async" line, matching the old pre-v9
** src/tr_1um_i2c_slave_async.cir's own structure -- and the
** LAYOUT-side extraction of the same top cell independently confirmed
** the same gap (src/tr_1um_i2c_slave_async.extracted:
** ".SUBCKT tr_1um_i2c_slave_async VSS", only one top pin). Neither
** side exposed the chip's real bond-pad nets as actual top-level
** PORTS, which is what let KLayout's LVS pin/port alignment fall back
** on ambiguous internal matching and produced the OSS_FRAME_GIO-level
** pin mismatches (HIZ2/HIZ7/HIZ9/HIZ10/HIZ15/OUT13) seen in
** src/LVS_error.lvsdb. Fix: rename each pad's carrying net to the
** pad's own canonical name (e.g. P1's net was "IN5") and declare all
** 16 as real subckt ports; see design_notes.md for the full writeup.

** sch_path: /Users/okamura/Dropbox/91_OpenPDK/TR-1um/libs.tech/xschem/TR-1um_frame/OSS_FRAME_GIO.sch
.subckt OSS_FRAME_GIO P1 VDD P2 P15 P14 P3 P4 P13 P5 P12 P6 P11 P10 P7 P9 VSS HIZ1 HIZ2 HIZ9 HIZ10 HIZ3 HIZ4 HIZ11 HIZ5 HIZ12 HIZ6
+ HIZ13 HIZ14 HIZ7 HIZ15 OUT1 OUT2 OUT9 OUT10 OUT3 OUT4 OUT11 OUT5 OUT12 OUT6 OUT13 OUT14 OUT7 OUT15
*.PININFO P1:B P2:B P3:B P4:B P5:B P6:B P7:B VSS:B VDD:B P15:B P14:B P13:B P12:B P11:B P10:B P9:B HIZ1:I OUT1:I HIZ2:I OUT2:I
*+ HIZ3:I OUT3:I HIZ4:I OUT4:I HIZ5:I OUT5:I HIZ6:I OUT6:I HIZ7:I OUT7:I HIZ15:I OUT15:I HIZ14:I OUT14:I HIZ13:I OUT13:I HIZ12:I OUT12:I
*+ HIZ11:I OUT11:I HIZ10:I OUT10:I HIZ9:I OUT9:I
x1 VDD P1 VSS HIZ1 OUT1 OSS_ESD_5V_DIO
x2 VDD VSS OSS_ESD_5V_VDD
x3 VDD VSS OSS_ESD_5V_VSS
x4 VDD P2 VSS HIZ2 OUT2 OSS_ESD_5V_DIO
x5 VDD P3 VSS HIZ3 OUT3 OSS_ESD_5V_DIO
x6 VDD P4 VSS HIZ4 OUT4 OSS_ESD_5V_DIO
x7 VDD P5 VSS HIZ5 OUT5 OSS_ESD_5V_DIO
x8 VDD P6 VSS HIZ6 OUT6 OSS_ESD_5V_DIO
x9 VDD P7 VSS HIZ7 OUT7 OSS_ESD_5V_DIO
x10 VDD P15 VSS HIZ15 OUT15 OSS_ESD_5V_DIO
x11 VDD P14 VSS HIZ14 OUT14 OSS_ESD_5V_DIO
x12 VDD P13 VSS HIZ13 OUT13 OSS_ESD_5V_DIO
x13 VDD P12 VSS HIZ12 OUT12 OSS_ESD_5V_DIO
x14 VDD P11 VSS HIZ11 OUT11 OSS_ESD_5V_DIO
x15 VDD P10 VSS HIZ10 OUT10 OSS_ESD_5V_DIO
x16 VDD P9 VSS HIZ9 OUT9 OSS_ESD_5V_DIO
.ends

* expanding   symbol:  OSS_ESD_5V_DIO.sym # of pins=6
** sym_path: /Users/okamura/Dropbox/91_OpenPDK/TR-1um/libs.tech/xschem/TR-1um_frame/OSS_ESD_5V_DIO.sym
** sch_path: /Users/okamura/Dropbox/91_OpenPDK/TR-1um/libs.tech/xschem/TR-1um_frame/OSS_ESD_5V_DIO.sch
.subckt OSS_ESD_5V_DIO VDD PAD VSS HIZ OUT
*.PININFO PAD:B VDD:B VSS:B HIZ:I OUT:I
MXM1 PAD PG VDD VDD PMOS w=300u l=2u
MXM2 PAD NG VSS VSS NMOSE w=150u l=2u
MXM3 PG PGG VDD VDD PMOS w=20.8u l=1u
MXM4 PG PGG VSS VSS NMOS w=6.8u l=1u
MXM5 PAD VDD VDD VDD PMOS w=200u l=2u
MXM6 PAD VSS VSS VSS NMOSE w=350u l=2u
MXM7 NG NGG VDD VDD PMOS w=20.8u l=1u
MXM8 NG NGG VSS VSS NMOS w=6.8u l=1u
MXM9 PGG HIZ net2 VDD PMOS w=10.4u l=1u
MXM10 net2 net1 VDD VDD PMOS w=10.4u l=1u
MXM11 PGG net1 VSS VSS NMOS w=3.4u l=1u
MXM12 PGG HIZ VSS VSS NMOS w=3.4u l=1u
MXM13 NGG net1 VDD VDD PMOS w=5.2u l=1u
MXM14 NGG ENB VDD VDD PMOS w=5.2u l=1u
MXM15 NGG ENB net3 VSS NMOS w=3.4u l=1u
MXM16 net3 net1 VSS VSS NMOS w=3.4u l=1u
MXM17 ENB HIZ VDD VDD PMOS w=5.2u l=1u
MXM18 ENB HIZ VSS VSS NMOS w=3.4u l=1u
DD1 VSS HIZ DN A=12.96p P=14.4u
MXM19 net1 OUT VDD VDD PMOS w=5.2u l=1u
MXM20 net1 OUT VSS VSS NMOS w=3.4u l=1u
DD2 VSS OUT DN A=12.96p P=14.4u
.ends

* expanding   symbol:  OSS_ESD_5V_VDD.sym # of pins=3
** sym_path: /Users/okamura/Dropbox/91_OpenPDK/TR-1um/libs.tech/xschem/TR-1um_frame/OSS_ESD_5V_VDD.sym
** sch_path: /Users/okamura/Dropbox/91_OpenPDK/TR-1um/libs.tech/xschem/TR-1um_frame/OSS_ESD_5V_VDD.sch
.subckt OSS_ESD_5V_VDD VDD VSS
*.PININFO VSS:B VDD:B VDD:B
MXM5 VSS VDD VDD VDD PMOS w=500u l=2u
MXM6 VDD VSS VSS VSS NMOSE w=500u l=2u
.ends

* expanding   symbol:  OSS_ESD_5V_VSS.sym # of pins=3
** sym_path: /Users/okamura/Dropbox/91_OpenPDK/TR-1um/libs.tech/xschem/TR-1um_frame/OSS_ESD_5V_VSS.sym
** sch_path: /Users/okamura/Dropbox/91_OpenPDK/TR-1um/libs.tech/xschem/TR-1um_frame/OSS_ESD_5V_VSS.sch
.subckt OSS_ESD_5V_VSS VDD VSS
*.PININFO VSS:B VDD:B VSS:B
MXM3 VSS VDD VDD VDD PMOS w=500u l=2u
MXM4 VDD VSS VSS VSS NMOSE w=500u l=2u
.ends

** Generated by script/gen_lvs_spice_v9.py from i2c_slave_async_net_v9_rowbuf.v
** (no xschem .sch involved -- see design_notes.md 77.45/77.46 for why/how)
.subckt i2c_slave_async_nrow_fm rst_n scl sda_in tx_data[0] tx_data[1] tx_data[2] tx_data[3] tx_data[4]
+ tx_data[5] tx_data[6] tx_data[7] sda_oe rx_data[0] rx_data[1] rx_data[2] rx_data[3] rx_data[4] rx_data[5]
+ rx_data[6] rx_data[7] rx_valid addr_match rw busy VDD GND
*.PININFO rst_n:I scl:I sda_in:I tx_data[0]:I tx_data[1]:I tx_data[2]:I tx_data[3]:I tx_data[4]:I tx_data[5]:I
+ tx_data[6]:I tx_data[7]:I sda_oe:O rx_data[0]:O rx_data[1]:O rx_data[2]:O rx_data[3]:O rx_data[4]:O
+ rx_data[5]:O rx_data[6]:O rx_data[7]:O rx_valid:O addr_match:O rw:O busy:O VDD:B GND:B
x_148_ VDD bit_cnt[0] _065_ GND INV_X1
x_149_ VDD addr_match _066_ GND INV_X1
x_150_ VDD rst_n _067_ GND INV_X1
x_151_ VDD sda_d _068_ GND INV_X1
x_152_ VDD _069_ scl_row2 sda_d GND NAND2
x_153_ VDD start_pulse sda_in_row3 _069_ GND NOR2
x_154_ VDD _008_ _067_ start_pulse GND NOR2
x_155_ VDD _009_ busy rst_n GND AND2_X1
x_156_ VDD _070_ phase[2] _004_ GND OR2
x_157_ VDD _071_ _005_ _070_ GND OR2
x_158_ VDD _071_ rx_valid GND INV_X1
x_159_ phase[0] _004_ VDD _072_ phase[2] GND NOR3
x_160_ VDD _073_ last_bit_pending _072_ GND NAND2
x_161_ shreg[5] rx_data[6] _073_ VDD _041_ GND MUX2
x_162_ shreg[4] rx_data[5] _073_ VDD _042_ GND MUX2
x_163_ shreg[3] rx_data[4] _073_ VDD _043_ GND MUX2
x_164_ shreg[2] rx_data[3] _073_ VDD _044_ GND MUX2
x_165_ shreg[1] rx_data[2] _073_ VDD _045_ GND MUX2
x_166_ shreg[0] rx_data[1] _073_ VDD _046_ GND MUX2
x_167_ sda_in_row3 rx_data[0] _073_ VDD _047_ GND MUX2
x_168_ VDD _074_ bit_cnt[1] bit_cnt[0] GND NOR2
x_169_ phase[0] phase[1] VDD _075_ _007_ GND NOR3
x_170_ phase[1] VDD _076_ _007_ phase[0] GND OR3
x_171_ VDD _077_ bit_cnt[2] _076_ GND NOR2
x_172_ VDD _078_ _074_ _077_ GND NAND2
x_173_ tx_data[6] txreg[6] _078_ VDD _048_ GND MUX2
x_174_ tx_data[5] txreg[5] _078_ VDD _049_ GND MUX2
x_175_ tx_data[4] txreg[4] _078_ VDD _050_ GND MUX2
x_176_ tx_data[3] txreg[3] _078_ VDD _051_ GND MUX2
x_177_ tx_data[2] txreg[2] _078_ VDD _052_ GND MUX2
x_178_ tx_data[1] txreg[1] _078_ VDD _053_ GND MUX2
x_179_ tx_data[0] txreg[0] _078_ VDD _054_ GND MUX2
x_180_ phase[0] phase[1] VDD _079_ phase[2] GND NOR3
x_181_ _075_ _079_ VDD _080_ _072_ GND NOR3
x_182_ VDD _081_ last_bit_pending _080_ GND NOR2
x_183_ VDD _082_ _005_ phase[1] GND OR2
x_184_ _005_ phase[1] VDD _083_ _007_ GND NOR3
x_185_ VDD _084_ _007_ _082_ GND OR2
x_186_ VDD _085_ phase[2] _082_ GND OR2
x_187_ _085_ _084_ VDD _086_ _071_ _080_ GND AND4_X1
x_188_ VDD _087_ sda_in_row0 _083_ GND NAND2
x_189_ VDD _088_ _066_ _006_ GND NOR2
x_190_ VDD _089_ _085_ _088_ GND NOR2
x_191_ VDD _090_ _073_ _087_ GND NAND2
x_192_ rx_valid _086_ _089_ _090_ VDD _091_ GND OR4
x_193_ _091_ phase[1] _081_ VDD _055_ GND MUX2
x_194_ VDD _092_ last_bit_pending _079_ GND NAND2
x_195_ VDD _093_ last_bit_pending _075_ GND NAND2
x_196_ _093_ VDD _056_ _073_ _092_ GND NAND3
x_197_ VDD _094_ bit_cnt[1] _086_ GND NAND2
x_198_ last_bit_pending _080_ VDD _095_ phase[2] GND NOR3
x_199_ VDD _096_ last_bit_pending _076_ GND AND2_X1
x_200_ VDD _097_ _080_ _096_ GND NOR2
x_201_ VDD _098_ bit_cnt[1] bit_cnt[0] GND NAND2
x_202_ VDD _099_ bit_cnt[1] bit_cnt[0] GND XOR2
x_203_ VDD _100_ _097_ _099_ GND NAND2
x_204_ VDD _057_ _094_ _100_ GND NAND2
x_205_ VDD _101_ bit_cnt[0] _086_ GND NAND2
x_206_ VDD _102_ _147_[0] _097_ GND NAND2
x_207_ VDD _058_ _101_ _102_ GND NAND2
x_208_ _003_ _002_ shreg[5] shreg[2] VDD _103_ GND OR4
x_209_ shreg[3] shreg[0] shreg[1] _103_ VDD _104_ GND NOR4
x_210_ _104_ addr_match _092_ VDD _059_ GND MUX2
x_211_ VDD _105_ bit_cnt[2] _086_ GND NAND2
x_212_ VDD _106_ bit_cnt[2] _098_ GND XNOR2
x_213_ VDD _107_ _097_ _106_ GND NAND2
x_214_ VDD _060_ _105_ _107_ GND NAND2
x_215_ sda_in_row0 rw _092_ VDD _061_ GND MUX2
x_216_ VDD _108_ _066_ rw GND NOR2
x_217_ VDD _109_ _085_ _108_ GND NOR2
x_218_ _083_ _086_ _097_ _109_ VDD _110_ GND NOR4
x_219_ VDD _062_ _095_ _110_ GND NOR2
x_220_ tx_data[7] txreg[7] _078_ VDD _063_ GND MUX2
x_221_ shreg[6] rx_data[7] _073_ VDD _064_ GND MUX2
x_222_ tx_data[7] txreg[5] bit_cnt[1] VDD _111_ GND MUX2
x_223_ VDD _112_ _065_ _111_ GND NAND2
x_224_ txreg[6] txreg[4] bit_cnt[1] VDD _113_ GND MUX2
x_225_ VDD _114_ bit_cnt[0] _113_ GND NAND2
x_226_ _114_ VDD _115_ _077_ _112_ GND NAND3
x_227_ VDD _116_ bit_cnt[2] _075_ GND NAND2
x_228_ txreg[2] txreg[0] bit_cnt[1] VDD _117_ GND MUX2
x_229_ txreg[3] txreg[1] bit_cnt[1] VDD _118_ GND MUX2
x_230_ _117_ _118_ _065_ VDD _119_ GND MUX2
x_231_ VDD _120_ _116_ _119_ GND NOR2
x_232_ VDD _121_ _066_ _085_ GND NOR2
x_233_ _120_ _121_ VDD _122_ rx_valid GND NOR3
x_234_ VDD _001_ _115_ _122_ GND NAND2
x_235_ _147_[1] _147_[2] VDD _000_ bit_cnt[0] GND NOR3
x_236_ _068_ VDD _123_ sda_in_row3 scl_row2 GND NAND3
x_237_ VDD busy_clr rst_n _123_ GND NAND2
x_269_ VDD _144_ _059_ addr_match _008_ GND scl_row0 DFFRB
x_270_ VDD _147_[0] _058_ bit_cnt[0] _008_ GND scl_row1 DFFRB
x_271_ VDD _147_[1] _057_ bit_cnt[1] _008_ GND scl_row1 DFFRB
x_272_ VDD _147_[2] _060_ bit_cnt[2] _008_ GND scl_row1 DFFRB
x_273_ VDD _006_ _061_ rw _008_ GND scl_row0 DFFRB
x_274_ VDD _005_ _056_ phase[0] _008_ GND scl_row0 DFFRB
x_275_ VDD _004_ _055_ phase[1] _008_ GND scl_row0 DFFRB
x_276_ VDD _007_ _062_ phase[2] _008_ GND scl_row0 DFFRB
x_277_ VDD _143_ _054_ txreg[0] _009_ GND scl_n_row2 DFFRB
x_278_ VDD _142_ _053_ txreg[1] _009_ GND scl_n_row2 DFFRB
x_279_ VDD _141_ _052_ txreg[2] _009_ GND scl_n_row2 DFFRB
x_280_ VDD _140_ _051_ txreg[3] _009_ GND scl_n_row2 DFFRB
x_281_ VDD _139_ _050_ txreg[4] _009_ GND scl_n_row2 DFFRB
x_282_ VDD _138_ _049_ txreg[5] _009_ GND scl_n_row1 DFFRB
x_283_ VDD _137_ _048_ txreg[6] _009_ GND scl_n_row2 DFFRB
x_284_ VDD _145_ _063_ txreg[7] _009_ GND scl_n_row1 DFFRB
x_285_ VDD _136_ _047_ rx_data[0] _008_ GND scl_row2 DFFRB
x_286_ VDD _135_ _046_ rx_data[1] _008_ GND scl_row3 DFFRB
x_287_ VDD _134_ _045_ rx_data[2] _008_ GND scl_row3 DFFRB
x_288_ VDD _133_ _044_ rx_data[3] _008_ GND scl_row3 DFFRB
x_289_ VDD _132_ _043_ rx_data[4] _008_ GND scl_row3 DFFRB
x_290_ VDD _131_ _042_ rx_data[5] _008_ GND scl_row3 DFFRB
x_291_ VDD _130_ _041_ rx_data[6] _008_ GND scl_row3 DFFRB
x_292_ VDD _125_ _064_ rx_data[7] _008_ GND scl_row3 DFFRB
x_293_ VDD sda_oe _001_ sda_oe_r _009_ GND scl_n_row1 DFFRB
x_294_ VDD _124_ _000_ last_bit_pending _008_ GND scl_row1 DFFRB
x_295_ VDD _128_ sda_in_row3 shreg[0] _008_ GND scl_row2 DFFRB
x_296_ VDD _126_ shreg[0] shreg[1] _008_ GND scl_row3 DFFRB
x_297_ VDD _127_ shreg[1] shreg[2] _008_ GND scl_row3 DFFRB
x_298_ VDD _129_ shreg[2] shreg[3] _008_ GND scl_row3 DFFRB
x_299_ VDD _002_ shreg[3] shreg[4] _008_ GND scl_row3 DFFRB
x_300_ VDD _146_ shreg[4] shreg[5] _008_ GND scl_row3 DFFRB
x_301_ VDD _003_ shreg[5] shreg[6] _008_ GND scl_row3 DFFRB
xu_del_sda VDD sda_in_row3 sda_d GND DEL1
xu_inv_scl VDD scl_row2 scl_n GND INV_X1
xu_lat_q VDD busy busy_clr qn GND NOR2
xu_lat_qn VDD qn start_pulse busy GND NOR2
xu_buf_scl_row0 VDD scl_buf scl_row0 GND BUF_X1
xu_buf_scl_row1 VDD scl_buf scl_row1 GND BUF_X1
xu_buf_scl_row2 VDD scl_buf scl_row2 GND BUF_X1
xu_buf_scl_row3 VDD scl_buf scl_row3 GND BUF_X1
xu_buf_scl_n_row1 VDD scl_n scl_n_row1 GND BUF_X1
xu_buf_scl_n_row2 VDD scl_n scl_n_row2 GND BUF_X1
xu_bufth_scl VDD scl scl_buf GND BUFTH
xu_bufth_sda_in VDD sda_in sda_in_buf GND BUFTH
xu_buf_sda_in_row0 VDD sda_in_buf sda_in_row0 GND BUF_X1
xu_buf_sda_in_row3 VDD sda_in_buf sda_in_row3 GND BUF_X1
** FILL3 decoupling-cap devices (design_notes.md 77.47) --
** one PMOS+NMOS pair per real placed instance, L/W from real
** device extraction against LEF/TR-1um_STDCELL.gds.
** FILL2 is instantiated as a subcircuit instead, below
** (design_notes.md round-4 fix, 2026-08-31 -- see
** FILL2_SUBCKT_BODY's comment for why).
xFILL2_1 VDD GND FILL2
xFILL2_2 VDD GND FILL2
xFILL2_3 VDD GND FILL2
xFILL2_4 VDD GND FILL2
xFILL2_5 VDD GND FILL2
xFILL2_6 VDD GND FILL2
xFILL2_7 VDD GND FILL2
xFILL2_8 VDD GND FILL2
xFILL2_9 VDD GND FILL2
xFILL2_10 VDD GND FILL2
xFILL2_11 VDD GND FILL2
xFILL2_12 VDD GND FILL2
xFILL2_13 VDD GND FILL2
xFILL2_14 VDD GND FILL2
xFILL2_15 VDD GND FILL2
xFILL2_16 VDD GND FILL2
xFILL2_17 VDD GND FILL2
xFILL2_18 VDD GND FILL2
xFILL2_19 VDD GND FILL2
xFILL2_20 VDD GND FILL2
xFILL2_21 VDD GND FILL2
xFILL2_22 VDD GND FILL2
xFILL2_23 VDD GND FILL2
xFILL2_24 VDD GND FILL2
xFILL2_25 VDD GND FILL2
xFILL2_26 VDD GND FILL2
xFILL2_27 VDD GND FILL2
xFILL2_28 VDD GND FILL2
xFILL2_29 VDD GND FILL2
xFILL2_30 VDD GND FILL2
xFILL2_31 VDD GND FILL2
xFILL2_32 VDD GND FILL2
xFILL2_33 VDD GND FILL2
xFILL2_34 VDD GND FILL2
xFILL2_35 VDD GND FILL2
xFILL2_36 VDD GND FILL2
M_FILL3_1_p VDD GND VDD VDD PMOS w=21.2u l=8.6u
M_FILL3_1_n GND VDD GND GND NMOS w=13.1u l=8.6u
M_FILL3_2_p VDD GND VDD VDD PMOS w=21.2u l=8.6u
M_FILL3_2_n GND VDD GND GND NMOS w=13.1u l=8.6u
M_FILL3_3_p VDD GND VDD VDD PMOS w=21.2u l=8.6u
M_FILL3_3_n GND VDD GND GND NMOS w=13.1u l=8.6u
M_FILL3_4_p VDD GND VDD VDD PMOS w=21.2u l=8.6u
M_FILL3_4_n GND VDD GND GND NMOS w=13.1u l=8.6u
M_FILL3_5_p VDD GND VDD VDD PMOS w=21.2u l=8.6u
M_FILL3_5_n GND VDD GND GND NMOS w=13.1u l=8.6u
M_FILL3_6_p VDD GND VDD VDD PMOS w=21.2u l=8.6u
M_FILL3_6_n GND VDD GND GND NMOS w=13.1u l=8.6u
M_FILL3_7_p VDD GND VDD VDD PMOS w=21.2u l=8.6u
M_FILL3_7_n GND VDD GND GND NMOS w=13.1u l=8.6u
M_FILL3_8_p VDD GND VDD VDD PMOS w=21.2u l=8.6u
M_FILL3_8_n GND VDD GND GND NMOS w=13.1u l=8.6u
M_FILL3_9_p VDD GND VDD VDD PMOS w=21.2u l=8.6u
M_FILL3_9_n GND VDD GND GND NMOS w=13.1u l=8.6u
M_FILL3_10_p VDD GND VDD VDD PMOS w=21.2u l=8.6u
M_FILL3_10_n GND VDD GND GND NMOS w=13.1u l=8.6u
M_FILL3_11_p VDD GND VDD VDD PMOS w=21.2u l=8.6u
M_FILL3_11_n GND VDD GND GND NMOS w=13.1u l=8.6u
M_FILL3_12_p VDD GND VDD VDD PMOS w=21.2u l=8.6u
M_FILL3_12_n GND VDD GND GND NMOS w=13.1u l=8.6u
M_FILL3_13_p VDD GND VDD VDD PMOS w=21.2u l=8.6u
M_FILL3_13_n GND VDD GND GND NMOS w=13.1u l=8.6u
M_FILL3_14_p VDD GND VDD VDD PMOS w=21.2u l=8.6u
M_FILL3_14_n GND VDD GND GND NMOS w=13.1u l=8.6u
M_FILL3_15_p VDD GND VDD VDD PMOS w=21.2u l=8.6u
M_FILL3_15_n GND VDD GND GND NMOS w=13.1u l=8.6u
M_FILL3_16_p VDD GND VDD VDD PMOS w=21.2u l=8.6u
M_FILL3_16_n GND VDD GND GND NMOS w=13.1u l=8.6u
M_FILL3_17_p VDD GND VDD VDD PMOS w=21.2u l=8.6u
M_FILL3_17_n GND VDD GND GND NMOS w=13.1u l=8.6u
M_FILL3_18_p VDD GND VDD VDD PMOS w=21.2u l=8.6u
M_FILL3_18_n GND VDD GND GND NMOS w=13.1u l=8.6u
M_FILL3_19_p VDD GND VDD VDD PMOS w=21.2u l=8.6u
M_FILL3_19_n GND VDD GND GND NMOS w=13.1u l=8.6u
M_FILL3_20_p VDD GND VDD VDD PMOS w=21.2u l=8.6u
M_FILL3_20_n GND VDD GND GND NMOS w=13.1u l=8.6u
M_FILL3_21_p VDD GND VDD VDD PMOS w=21.2u l=8.6u
M_FILL3_21_n GND VDD GND GND NMOS w=13.1u l=8.6u
M_FILL3_22_p VDD GND VDD VDD PMOS w=21.2u l=8.6u
M_FILL3_22_n GND VDD GND GND NMOS w=13.1u l=8.6u
M_FILL3_23_p VDD GND VDD VDD PMOS w=21.2u l=8.6u
M_FILL3_23_n GND VDD GND GND NMOS w=13.1u l=8.6u
M_FILL3_24_p VDD GND VDD VDD PMOS w=21.2u l=8.6u
M_FILL3_24_n GND VDD GND GND NMOS w=13.1u l=8.6u
M_FILL3_25_p VDD GND VDD VDD PMOS w=21.2u l=8.6u
M_FILL3_25_n GND VDD GND GND NMOS w=13.1u l=8.6u
M_FILL3_26_p VDD GND VDD VDD PMOS w=21.2u l=8.6u
M_FILL3_26_n GND VDD GND GND NMOS w=13.1u l=8.6u
M_FILL3_27_p VDD GND VDD VDD PMOS w=21.2u l=8.6u
M_FILL3_27_n GND VDD GND GND NMOS w=13.1u l=8.6u
M_FILL3_28_p VDD GND VDD VDD PMOS w=21.2u l=8.6u
M_FILL3_28_n GND VDD GND GND NMOS w=13.1u l=8.6u
M_FILL3_29_p VDD GND VDD VDD PMOS w=21.2u l=8.6u
M_FILL3_29_n GND VDD GND GND NMOS w=13.1u l=8.6u
M_FILL3_30_p VDD GND VDD VDD PMOS w=21.2u l=8.6u
M_FILL3_30_n GND VDD GND GND NMOS w=13.1u l=8.6u
M_FILL3_31_p VDD GND VDD VDD PMOS w=21.2u l=8.6u
M_FILL3_31_n GND VDD GND GND NMOS w=13.1u l=8.6u
M_FILL3_32_p VDD GND VDD VDD PMOS w=21.2u l=8.6u
M_FILL3_32_n GND VDD GND GND NMOS w=13.1u l=8.6u
M_FILL3_33_p VDD GND VDD VDD PMOS w=21.2u l=8.6u
M_FILL3_33_n GND VDD GND GND NMOS w=13.1u l=8.6u
M_FILL3_34_p VDD GND VDD VDD PMOS w=21.2u l=8.6u
M_FILL3_34_n GND VDD GND GND NMOS w=13.1u l=8.6u
M_FILL3_35_p VDD GND VDD VDD PMOS w=21.2u l=8.6u
M_FILL3_35_n GND VDD GND GND NMOS w=13.1u l=8.6u
M_FILL3_36_p VDD GND VDD VDD PMOS w=21.2u l=8.6u
M_FILL3_36_n GND VDD GND GND NMOS w=13.1u l=8.6u
M_FILL3_37_p VDD GND VDD VDD PMOS w=21.2u l=8.6u
M_FILL3_37_n GND VDD GND GND NMOS w=13.1u l=8.6u
M_FILL3_38_p VDD GND VDD VDD PMOS w=21.2u l=8.6u
M_FILL3_38_n GND VDD GND GND NMOS w=13.1u l=8.6u
M_FILL3_39_p VDD GND VDD VDD PMOS w=21.2u l=8.6u
M_FILL3_39_n GND VDD GND GND NMOS w=13.1u l=8.6u
M_FILL3_40_p VDD GND VDD VDD PMOS w=21.2u l=8.6u
M_FILL3_40_n GND VDD GND GND NMOS w=13.1u l=8.6u
M_FILL3_41_p VDD GND VDD VDD PMOS w=21.2u l=8.6u
M_FILL3_41_n GND VDD GND GND NMOS w=13.1u l=8.6u
M_FILL3_42_p VDD GND VDD VDD PMOS w=21.2u l=8.6u
M_FILL3_42_n GND VDD GND GND NMOS w=13.1u l=8.6u
M_FILL3_43_p VDD GND VDD VDD PMOS w=21.2u l=8.6u
M_FILL3_43_n GND VDD GND GND NMOS w=13.1u l=8.6u
M_FILL3_44_p VDD GND VDD VDD PMOS w=21.2u l=8.6u
M_FILL3_44_n GND VDD GND GND NMOS w=13.1u l=8.6u
M_FILL3_45_p VDD GND VDD VDD PMOS w=21.2u l=8.6u
M_FILL3_45_n GND VDD GND GND NMOS w=13.1u l=8.6u
M_FILL3_46_p VDD GND VDD VDD PMOS w=21.2u l=8.6u
M_FILL3_46_n GND VDD GND GND NMOS w=13.1u l=8.6u
M_FILL3_47_p VDD GND VDD VDD PMOS w=21.2u l=8.6u
M_FILL3_47_n GND VDD GND GND NMOS w=13.1u l=8.6u
M_FILL3_48_p VDD GND VDD VDD PMOS w=21.2u l=8.6u
M_FILL3_48_n GND VDD GND GND NMOS w=13.1u l=8.6u
M_FILL3_49_p VDD GND VDD VDD PMOS w=21.2u l=8.6u
M_FILL3_49_n GND VDD GND GND NMOS w=13.1u l=8.6u
M_FILL3_50_p VDD GND VDD VDD PMOS w=21.2u l=8.6u
M_FILL3_50_n GND VDD GND GND NMOS w=13.1u l=8.6u
M_FILL3_51_p VDD GND VDD VDD PMOS w=21.2u l=8.6u
M_FILL3_51_n GND VDD GND GND NMOS w=13.1u l=8.6u
M_FILL3_52_p VDD GND VDD VDD PMOS w=21.2u l=8.6u
M_FILL3_52_n GND VDD GND GND NMOS w=13.1u l=8.6u
M_FILL3_53_p VDD GND VDD VDD PMOS w=21.2u l=8.6u
M_FILL3_53_n GND VDD GND GND NMOS w=13.1u l=8.6u
M_FILL3_54_p VDD GND VDD VDD PMOS w=21.2u l=8.6u
M_FILL3_54_n GND VDD GND GND NMOS w=13.1u l=8.6u
M_FILL3_55_p VDD GND VDD VDD PMOS w=21.2u l=8.6u
M_FILL3_55_n GND VDD GND GND NMOS w=13.1u l=8.6u
M_FILL3_56_p VDD GND VDD VDD PMOS w=21.2u l=8.6u
M_FILL3_56_n GND VDD GND GND NMOS w=13.1u l=8.6u
M_FILL3_57_p VDD GND VDD VDD PMOS w=21.2u l=8.6u
M_FILL3_57_n GND VDD GND GND NMOS w=13.1u l=8.6u
M_FILL3_58_p VDD GND VDD VDD PMOS w=21.2u l=8.6u
M_FILL3_58_n GND VDD GND GND NMOS w=13.1u l=8.6u
M_FILL3_59_p VDD GND VDD VDD PMOS w=21.2u l=8.6u
M_FILL3_59_n GND VDD GND GND NMOS w=13.1u l=8.6u
M_FILL3_60_p VDD GND VDD VDD PMOS w=21.2u l=8.6u
M_FILL3_60_n GND VDD GND GND NMOS w=13.1u l=8.6u
M_FILL3_61_p VDD GND VDD VDD PMOS w=21.2u l=8.6u
M_FILL3_61_n GND VDD GND GND NMOS w=13.1u l=8.6u
M_FILL3_62_p VDD GND VDD VDD PMOS w=21.2u l=8.6u
M_FILL3_62_n GND VDD GND GND NMOS w=13.1u l=8.6u
M_FILL3_63_p VDD GND VDD VDD PMOS w=21.2u l=8.6u
M_FILL3_63_n GND VDD GND GND NMOS w=13.1u l=8.6u
M_FILL3_64_p VDD GND VDD VDD PMOS w=21.2u l=8.6u
M_FILL3_64_n GND VDD GND GND NMOS w=13.1u l=8.6u
M_FILL3_65_p VDD GND VDD VDD PMOS w=21.2u l=8.6u
M_FILL3_65_n GND VDD GND GND NMOS w=13.1u l=8.6u
M_FILL3_66_p VDD GND VDD VDD PMOS w=21.2u l=8.6u
M_FILL3_66_n GND VDD GND GND NMOS w=13.1u l=8.6u
M_FILL3_67_p VDD GND VDD VDD PMOS w=21.2u l=8.6u
M_FILL3_67_n GND VDD GND GND NMOS w=13.1u l=8.6u
M_FILL3_68_p VDD GND VDD VDD PMOS w=21.2u l=8.6u
M_FILL3_68_n GND VDD GND GND NMOS w=13.1u l=8.6u
M_FILL3_69_p VDD GND VDD VDD PMOS w=21.2u l=8.6u
M_FILL3_69_n GND VDD GND GND NMOS w=13.1u l=8.6u
M_FILL3_70_p VDD GND VDD VDD PMOS w=21.2u l=8.6u
M_FILL3_70_n GND VDD GND GND NMOS w=13.1u l=8.6u
M_FILL3_71_p VDD GND VDD VDD PMOS w=21.2u l=8.6u
M_FILL3_71_n GND VDD GND GND NMOS w=13.1u l=8.6u
M_FILL3_72_p VDD GND VDD VDD PMOS w=21.2u l=8.6u
M_FILL3_72_n GND VDD GND GND NMOS w=13.1u l=8.6u
M_FILL3_73_p VDD GND VDD VDD PMOS w=21.2u l=8.6u
M_FILL3_73_n GND VDD GND GND NMOS w=13.1u l=8.6u
M_FILL3_74_p VDD GND VDD VDD PMOS w=21.2u l=8.6u
M_FILL3_74_n GND VDD GND GND NMOS w=13.1u l=8.6u
M_FILL3_75_p VDD GND VDD VDD PMOS w=21.2u l=8.6u
M_FILL3_75_n GND VDD GND GND NMOS w=13.1u l=8.6u
M_FILL3_76_p VDD GND VDD VDD PMOS w=21.2u l=8.6u
M_FILL3_76_n GND VDD GND GND NMOS w=13.1u l=8.6u
M_FILL3_77_p VDD GND VDD VDD PMOS w=21.2u l=8.6u
M_FILL3_77_n GND VDD GND GND NMOS w=13.1u l=8.6u
M_FILL3_78_p VDD GND VDD VDD PMOS w=21.2u l=8.6u
M_FILL3_78_n GND VDD GND GND NMOS w=13.1u l=8.6u
M_FILL3_79_p VDD GND VDD VDD PMOS w=21.2u l=8.6u
M_FILL3_79_n GND VDD GND GND NMOS w=13.1u l=8.6u
M_FILL3_80_p VDD GND VDD VDD PMOS w=21.2u l=8.6u
M_FILL3_80_n GND VDD GND GND NMOS w=13.1u l=8.6u
M_FILL3_81_p VDD GND VDD VDD PMOS w=21.2u l=8.6u
M_FILL3_81_n GND VDD GND GND NMOS w=13.1u l=8.6u
M_FILL3_82_p VDD GND VDD VDD PMOS w=21.2u l=8.6u
M_FILL3_82_n GND VDD GND GND NMOS w=13.1u l=8.6u
M_FILL3_83_p VDD GND VDD VDD PMOS w=21.2u l=8.6u
M_FILL3_83_n GND VDD GND GND NMOS w=13.1u l=8.6u
M_FILL3_84_p VDD GND VDD VDD PMOS w=21.2u l=8.6u
M_FILL3_84_n GND VDD GND GND NMOS w=13.1u l=8.6u
M_FILL3_85_p VDD GND VDD VDD PMOS w=21.2u l=8.6u
M_FILL3_85_n GND VDD GND GND NMOS w=13.1u l=8.6u
M_FILL3_86_p VDD GND VDD VDD PMOS w=21.2u l=8.6u
M_FILL3_86_n GND VDD GND GND NMOS w=13.1u l=8.6u
M_FILL3_87_p VDD GND VDD VDD PMOS w=21.2u l=8.6u
M_FILL3_87_n GND VDD GND GND NMOS w=13.1u l=8.6u
M_FILL3_88_p VDD GND VDD VDD PMOS w=21.2u l=8.6u
M_FILL3_88_n GND VDD GND GND NMOS w=13.1u l=8.6u
M_FILL3_89_p VDD GND VDD VDD PMOS w=21.2u l=8.6u
M_FILL3_89_n GND VDD GND GND NMOS w=13.1u l=8.6u
M_FILL3_90_p VDD GND VDD VDD PMOS w=21.2u l=8.6u
M_FILL3_90_n GND VDD GND GND NMOS w=13.1u l=8.6u
M_FILL3_91_p VDD GND VDD VDD PMOS w=21.2u l=8.6u
M_FILL3_91_n GND VDD GND GND NMOS w=13.1u l=8.6u
M_FILL3_92_p VDD GND VDD VDD PMOS w=21.2u l=8.6u
M_FILL3_92_n GND VDD GND GND NMOS w=13.1u l=8.6u
.ends

.subckt FILL2 VDD GND
*.PININFO GND:B VDD:B
MM7 VDD GND VDD VDD PMOS w=21.2u l=3.2u
MM2 GND VDD GND GND NMOS w=13.1u l=3.2u
.ends

** sch_path: /Users/okamura/Dropbox/91_OpenPDK/TR-1um/libs.tech/xschem/IP62_5_stdcell/AND2_X1.sch
.subckt AND2_X1 VDD Y A B GND
*.PININFO Y:O A:I B:I VDD:B GND:B
MM7 net1 B VDD VDD PMOS w=10.2u l=1u
MM1 net1 A VDD VDD PMOS w=10.2u l=1u
MM2 Y net1 VDD VDD PMOS w=10.2u l=1u
MM3 Y net1 GND GND NMOS w=3.4u l=1u
MM4 net1 A net2 GND NMOS w=3.4u l=1u
MM5 net2 B GND GND NMOS w=3.4u l=1u
.ends

** sch_path: /Users/okamura/Dropbox/91_OpenPDK/TR-1um/libs.tech/xschem/IP62_5_stdcell/AND4_X1.sch
.subckt AND4_X1 D C VDD Y A B GND
*.PININFO Y:O A:I B:I VDD:B GND:B C:I D:I
MM7 net1 A net4 GND NMOS w=3.4u l=1u
MM5 net3 C net2 GND NMOS w=3.4u l=1u
MM8 Y net1 GND GND NMOS w=3.4u l=1u
MM10 net2 D GND GND NMOS w=3.4u l=1u
MM6 net4 B net3 GND NMOS w=3.4u l=1u
MM11 net1 A VDD VDD PMOS w=10.2u l=1u
MM1 net1 D VDD VDD PMOS w=10.2u l=1u
MM3 net1 C VDD VDD PMOS w=10.2u l=1u
MM4 Y net1 VDD VDD PMOS w=10.2u l=1u
MM2 net1 B VDD VDD PMOS w=10.2u l=1u
.ends

** sch_path: /Users/okamura/Dropbox/98_LSI_Design/TR-1um_Async_I2C/LEF/BUFTH.sch
.subckt BUFTH VDD A Y GND
*.PININFO A:I Y:O VDD:B GND:B
MM9 MID A net1 VDD PMOS w=5.1u l=1u
MM2 Y MID VDD VDD PMOS w=10.2u l=1u
MM8 MID A net2 GND NMOS w=3.4u l=1u
MM1 Y MID GND GND NMOS w=3.4u l=1u
MM6 GND MID net1 VDD PMOS w=10.2u l=1u
MM3 VDD MID net2 GND NMOS w=6.8u l=1u
MM5 net2 A GND GND NMOS w=3.4u l=1u
MM4 net1 A VDD VDD PMOS w=5.1u l=1u
.ends

** sch_path: /Users/okamura/Dropbox/91_OpenPDK/TR-1um/libs.tech/xschem/IP62_5_stdcell/BUF_X1.sch
.subckt BUF_X1 VDD A Y GND
*.PININFO A:I Y:O VDD:B GND:B
MM7 net1 A VDD VDD PMOS w=10.2u l=1u
MM1 Y net1 VDD VDD PMOS w=10.2u l=1u
MM3 net1 A GND GND NMOS w=3.4u l=1u
MM2 Y net1 GND GND NMOS w=3.4u l=1u
.ends

** sch_path: /Users/okamura/Dropbox/91_OpenPDK/TR-1um/libs.tech/xschem/IP62_5_stdcell/DEL1.sch
.subckt DEL1 VDD A Y GND
*.PININFO A:I Y:O VDD:B GND:B
MM9 net3 A VDD VDD PMOS w=10.2u l=1u
MM2 Y net1 VDD VDD PMOS w=10.2u l=1u m=2
MM8 net3 A GND GND NMOS w=3.4u l=1u
MM1 Y net1 GND GND NMOS w=3.4u l=1u m=2
MM4 net2 net3 VDD VDD PMOS w=10.2u l=2u
MM6 net1 net2 VDD VDD PMOS w=10.2u l=2u
MM7 net2 net3 GND GND NMOS w=3.4u l=2u
MM3 net1 net2 GND GND NMOS w=3.4u l=2u
.ends

** sch_path: /Users/okamura/Dropbox/98_LSI_Design/TR-1um_Async_I2C/LEF/DFFRB.sch
.subckt DFFRB VDD QB D Q RSTB GND CK
*.PININFO VDD:B GND:B D:I QB:O CK:I Q:O RSTB:I
MM2 net1 D VDD VDD PMOS w=5.2u l=1u
MM1 net2 CKP net1 VDD PMOS w=5.2u l=1u
MM7 net2 CKB net3 GND NMOS w=3.4u l=1u
MM8 net3 D GND GND NMOS w=3.4u l=1u
MM10 QM net2 VDD VDD PMOS w=5.2u l=1u
MM11 QM net2 GND GND NMOS w=3.4u l=1u
MM13 net4 QM GND GND NMOS w=3.4u l=1u
MM15 net4 CKP net2 GND NMOS w=3.4u l=1u
MM22 QB QS VDD VDD PMOS w=10.4u l=1u
MM3 net4 QM VDD VDD PMOS w=5.2u l=1u
MM4 net2 CKB net4 VDD PMOS w=5.2u l=1u
MM5 QS CKP QM GND NMOS w=3.4u l=1u
MM6 QM CKB QS VDD PMOS w=5.2u l=1u
MM9 net5 QB GND GND NMOS w=3.4u l=1u
MM12 net5 QB VDD VDD PMOS w=5.2u l=1u
MM14 net5 CKB QS GND NMOS w=3.4u l=1u
MM16 QS CKP net5 VDD PMOS w=5.2u l=1u
MM17 QB RSTB net6 GND NMOS w=3.4u l=1u
MM18 Q QB VDD VDD PMOS w=10.4u l=1u
MM19 Q QB GND GND NMOS w=3.4u l=1u
MM20 CKB CK VDD VDD PMOS w=10.4u l=1u
MM21 CKB CK GND GND NMOS w=3.4u l=1u
MM23 CKP CKB VDD VDD PMOS w=10.4u l=1u
MM24 CKP CKB GND GND NMOS w=3.4u l=1u
MM25 net6 QS GND GND NMOS w=3.4u l=1u
MM26 QB RSTB VDD VDD PMOS w=10.4u l=1u
.ends

.subckt INV_X1 VDD A Y GND
*.PININFO A:I Y:O GND:B VDD:B
MM7 Y A VDD VDD PMOS w=10.2u l=1u
MM2 Y A GND GND NMOS w=3.4u l=1u
.ends

** sch_path: /Users/okamura/Dropbox/91_OpenPDK/TR-1um/libs.tech/xschem/IP62_5_stdcell/MUX2.sch
.subckt MUX2 A B S VDD Y GND
*.PININFO S:I Y:O VDD:B GND:B B:I A:I
MM13 SB S VDD VDD PMOS w=6.8u l=1u
MM8 net2 S net3 VDD PMOS w=6.8u l=1u
MM12 SB S GND GND NMOS w=3.4u l=1u
MM6 net2 SB net3 GND NMOS w=3.4u l=1u
MM11 net1 B VDD VDD PMOS w=6.8u l=1u
MM14 net1 B GND GND NMOS w=3.4u l=1u
MM15 net2 A VDD VDD PMOS w=6.8u l=1u
MM16 net2 A GND GND NMOS w=3.4u l=1u
MM3 net1 SB net3 VDD PMOS w=6.8u l=1u
MM5 net1 S net3 GND NMOS w=3.4u l=1u
MM1 Y net3 VDD VDD PMOS w=11.2u l=1u
MM2 Y net3 GND GND NMOS w=3.4u l=1u
.ends

** sch_path: /Users/okamura/Dropbox/91_OpenPDK/TR-1um/libs.tech/xschem/IP62_5_stdcell/NAND2.sch
.subckt NAND2 VDD Y A B GND
*.PININFO B:I A:I Y:O GND:B VDD:B
MM7 Y A VDD VDD PMOS w=10.2u l=1u
MM1 Y B VDD VDD PMOS w=10.2u l=1u
MM2 Y B net1 GND NMOS w=3.4u l=1u
MM3 net1 A GND GND NMOS w=3.4u l=1u
.ends

** sch_path: /Users/okamura/Dropbox/91_OpenPDK/TR-1um/libs.tech/xschem/IP62_5_stdcell/NAND3.sch
.subckt NAND3 C VDD Y A B GND
*.PININFO B:I A:I Y:O GND:B VDD:B C:I
MM1 Y A VDD VDD PMOS w=10.2u l=1u
MM4 Y B VDD VDD PMOS w=10.2u l=1u
MM6 Y C VDD VDD PMOS w=10.2u l=1u
MM7 Y C net1 GND NMOS w=3.4u l=1u
MM2 net1 B net2 GND NMOS w=3.4u l=1u
MM3 net2 A GND GND NMOS w=3.4u l=1u
.ends

** sch_path: /Users/okamura/Dropbox/91_OpenPDK/TR-1um/libs.tech/xschem/IP62_5_stdcell/NOR2.sch
.subckt NOR2 VDD Y A B GND
*.PININFO A:I B:I Y:O VDD:B GND:B
MM7 net1 A VDD VDD PMOS w=10.2u l=1u
MM1 Y B net1 VDD PMOS w=10.2u l=1u
MM2 Y A GND GND NMOS w=3.4u l=1u
MM3 Y B GND GND NMOS w=3.4u l=1u
.ends

** sch_path: /Users/okamura/Dropbox/91_OpenPDK/TR-1um/libs.tech/xschem/IP62_5_stdcell/NOR3.sch
.subckt NOR3 B C VDD Y A GND
*.PININFO A:I B:I Y:O VDD:B GND:B C:I
MM7 net1 B VDD VDD PMOS w=10.2u l=1u
MM2 net2 A net1 VDD PMOS w=10.2u l=1u
MM3 Y C net2 VDD PMOS w=10.2u l=1u
MM1 Y B GND GND NMOS w=3.4u l=1u
MM4 Y C GND GND NMOS w=3.4u l=1u
MM5 Y A GND GND NMOS w=3.4u l=1u
.ends

** sch_path: /Users/okamura/Dropbox/91_OpenPDK/TR-1um/libs.tech/xschem/IP62_5_stdcell/NOR4.sch
.subckt NOR4 A B C D VDD Y GND
*.PININFO A:I B:I Y:O VDD:B GND:B C:I D:I
MM8 net1 B VDD VDD PMOS w=10.2u l=1u
MM2 net2 A net1 VDD PMOS w=10.2u l=1u
MM3 net3 C net2 VDD PMOS w=10.2u l=1u
MM6 Y D net3 VDD PMOS w=10.2u l=1u
MM9 Y D GND GND NMOS w=3.4u l=1u
MM1 Y B GND GND NMOS w=3.4u l=1u
MM4 Y C GND GND NMOS w=3.4u l=1u
MM5 Y A GND GND NMOS w=3.4u l=1u
.ends

** sch_path: /Users/okamura/Dropbox/91_OpenPDK/TR-1um/libs.tech/xschem/IP62_5_stdcell/OR2.sch
.subckt OR2 VDD Y A B GND
*.PININFO A:I B:I Y:O VDD:B GND:B
MM7 net2 B VDD VDD PMOS w=10.2u l=1u
MM2 net1 A net2 VDD PMOS w=10.2u l=1u
MM4 Y net1 VDD VDD PMOS w=10.2u l=1u
MM1 net1 B GND GND NMOS w=3.4u l=1u
MM3 net1 A GND GND NMOS w=3.4u l=1u
MM5 Y net1 GND GND NMOS w=3.4u l=1u
.ends

** sch_path: /Users/okamura/Dropbox/91_OpenPDK/TR-1um/libs.tech/xschem/IP62_5_stdcell/OR3.sch
.subckt OR3 C VDD Y A B GND
*.PININFO A:I B:I Y:O VDD:B GND:B C:I
MM8 net1 B VDD VDD PMOS w=10.2u l=1u
MM2 net2 A net1 VDD PMOS w=10.2u l=1u
MM3 net3 C net2 VDD PMOS w=10.2u l=1u
MM7 Y net3 VDD VDD PMOS w=10.2u l=1u
MM9 Y net3 GND GND NMOS w=3.4u l=1u
MM1 net3 C GND GND NMOS w=3.4u l=1u
MM4 net3 A GND GND NMOS w=3.4u l=1u
MM5 net3 B GND GND NMOS w=3.4u l=1u
.ends

** sch_path: /Users/okamura/Dropbox/91_OpenPDK/TR-1um/libs.tech/xschem/IP62_5_stdcell/OR4.sch
.subckt OR4 A B C D VDD Y GND
*.PININFO B:I A:I Y:O VDD:B GND:B C:I D:I
MM10 net1 B VDD VDD PMOS w=10.2u l=1u
MM2 net2 A net1 VDD PMOS w=10.2u l=1u
MM3 net4 C net2 VDD PMOS w=10.2u l=1u
MM7 Y net3 VDD VDD PMOS w=10.2u l=1u
MM9 net4 D net3 VDD PMOS w=10.2u l=1u
MM11 net3 A GND GND NMOS w=3.4u l=1u
MM1 net3 B GND GND NMOS w=3.4u l=1u
MM4 net3 C GND GND NMOS w=3.4u l=1u
MM5 net3 D GND GND NMOS w=3.4u l=1u
MM6 Y net3 GND GND NMOS w=3.4u l=1u
.ends

** sch_path: /Users/okamura/Dropbox/98_LSI_Design/TR-1um_Async_I2C/LEF/XNOR2.sch
.subckt XNOR2 VDD Y A B GND
*.PININFO VDD:B GND:B A:I B:I Y:O
MM10 net1 A VDD VDD PMOS w=10.2u l=1u
MM1 net1 B VDD VDD PMOS w=10.2u l=1u
MM2 Y net1 VDD VDD PMOS w=10.2u l=1u
MM3 net4 B VDD VDD PMOS w=10.2u l=1u
MM4 Y A net4 VDD PMOS w=10.2u l=1u
MM11 net1 B net3 GND NMOS w=3.4u l=1u
MM5 net3 A GND GND NMOS w=3.4u l=1u
MM6 Y net1 net2 GND NMOS w=3.4u l=1u
MM7 net2 A GND GND NMOS w=3.4u l=1u
MM8 net2 B GND GND NMOS w=3.4u l=1u
.ends

** sch_path: /Users/okamura/Dropbox/98_LSI_Design/TR-1um_Async_I2C/LEF/XOR2.sch
.subckt XOR2 VDD Y A B GND
*.PININFO VDD:B GND:B A:I B:I Y:O
MM10 net1 A VDD VDD PMOS w=10.2u l=1u
MM1 net2 B net1 VDD PMOS w=10.2u l=1u
MM8 net3 A VDD VDD PMOS w=10.2u l=1u
MM2 net3 B VDD VDD PMOS w=10.2u l=1u
MM9 Y net2 net3 VDD PMOS w=10.2u l=1u
MM3 net2 A GND GND NMOS w=3.4u l=1u
MM4 net2 B GND GND NMOS w=3.4u l=1u
MM5 Y net2 GND GND NMOS w=3.4u l=1u
MM7 net4 B GND GND NMOS w=3.4u l=1u
MM6 Y A net4 GND NMOS w=3.4u l=1u
.ends

.subckt tr_1um_i2c_slave_async P1 P2 P3 P4 P5 P6 P7 VSS P9 P10 P11 P12 P13 P14 P15 VDD
x1 P1 VDD P2 P15 P14 P3 P4 P13
+ P5 P12 P6 P11 P10 P7 P9 VSS
+ P7 VDD VSS VSS P7 P7 P7 P7
+ P7 P7 SDA_O P7 VDD VDD NET_5 NC_OUT2
+ NC_OUT9 NC_OUT10 NET_6 NET_4 NET_1 NET_2 NET_0 NET_3
+ VSS NET_7 NC_OUT7 NC_OUT15 OSS_FRAME_GIO
x2 P15 P2 P13 P12 P11 P5 P6 P4
+ P1 P3 P14 SDA_O NET_0 NET_1 NET_2 NET_3
+ NET_4 NET_5 NET_6 NET_7 NC_CORE_rx_valid NC_CORE_addr_match NC_CORE_rw NC_CORE_busy
+ VDD VSS i2c_slave_async_nrow_fm
.ends
