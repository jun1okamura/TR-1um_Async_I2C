** tr_1um_i2c_slave_async_v10_lvs.spice -- chip-level LVS reference netlist (V10,
** core+GIO only -- RING_OSC not yet integrated, see
** gen_lvs_spice_ringosc_v10.py for that).
** Generated by script/gen_lvs_spice_top_v10.py from:
**   1) schematic/i2c_slave_async_nrow_fm_v10.spice (core, LVS-clean per
**      design_notes.md 108.51 -- "V10コアセル単体LVSクリーン達成")
**   2) simulations/OSS_FRAME_GIO.spice (GIO pad-ring frame, transistor
**      level, unchanged from V9 -- same physical frame)
**   3) schematic/gio_connections.json (base GIO<->core connection map,
**      derived + cross-verified design_notes.md 78.1/78.4 for V9) with
**      the 20 signal-net terminals OVERRIDDEN from
**      schematic/v10_signal_routing_plan.json's own per-net "terminal"
**      field (V10's pad-pairing-aware reassignment, design_notes.md
**      108.57) -- see this script's own module docstring for exactly
**      which terminals differ from V9's assignment and why the rest of
**      the 43-terminal map is safely reused verbatim.
** x1 = OSS_FRAME_GIO, x2 = i2c_slave_async_nrow_fm. Nets prefixed NC_
** are genuinely unconnected on both sides -- each gets its own unique
** floating net name so LVS sees them as independently floating,
** matching the real chip.
** Top subckt declares its 16 real bond-pad ports explicitly (P1-P7,
** VSS, P9-P15, VDD -- P8 does not exist in this frame), matching v9's
** own top-level-pin fix (design_notes.md 79.13).

** sch_path: /Users/okamura/Dropbox/91_OpenPDK/TR-1um/libs.tech/xschem/TR-1um_frame/OSS_FRAME_GIO.sch
.subckt OSS_FRAME_GIO P1 VDD P2 P15 P14 P3 P4 P13 P5 P12 P6 P11 P10 P7 P9 VSS HIZ1 HIZ2 HIZ9 HIZ10 HIZ3 HIZ4 HIZ11 HIZ5 HIZ12 HIZ6
+ HIZ13 HIZ14 HIZ7 HIZ15 OUT1 OUT2 OUT9 OUT10 OUT3 OUT4 OUT11 OUT5 OUT12 OUT6 OUT13 OUT14 OUT7 OUT15
*.PININFO P1:B P2:B P3:B P4:B P5:B P6:B P7:B VSS:B VDD:B P15:B P14:B P13:B P12:B P11:B P10:B P9:B HIZ1:I OUT1:I HIZ2:I OUT2:I
*+ HIZ3:I OUT3:I HIZ4:I OUT4:I HIZ5:I OUT5:I HIZ6:I OUT6:I HIZ7:I OUT7:I HIZ15:I OUT15:I HIZ14:I OUT14:I HIZ13:I OUT13:I HIZ12:I OUT12:I
*+ HIZ11:I OUT11:I HIZ10:I OUT10:I HIZ9:I OUT9:I
x1 VDD P1 VSS HIZ1 OUT1 OSS_ESD_5V_DIO
x2 VDD VSS OSS_ESD_5V_VDD
x3 VDD VSS OSS_ESD_5V_VSS
x4 VDD P2 VSS HIZ2 OUT2 OSS_ESD_5V_DIO
x5 VDD P3 VSS HIZ3 OUT3 OSS_ESD_5V_DIO
x6 VDD P4 VSS HIZ4 OUT4 OSS_ESD_5V_DIO
x7 VDD P5 VSS HIZ5 OUT5 OSS_ESD_5V_DIO
x8 VDD P6 VSS HIZ6 OUT6 OSS_ESD_5V_DIO
x9 VDD P7 VSS HIZ7 OUT7 OSS_ESD_5V_DIO
x10 VDD P15 VSS HIZ15 OUT15 OSS_ESD_5V_DIO
x11 VDD P14 VSS HIZ14 OUT14 OSS_ESD_5V_DIO
x12 VDD P13 VSS HIZ13 OUT13 OSS_ESD_5V_DIO
x13 VDD P12 VSS HIZ12 OUT12 OSS_ESD_5V_DIO
x14 VDD P11 VSS HIZ11 OUT11 OSS_ESD_5V_DIO
x15 VDD P10 VSS HIZ10 OUT10 OSS_ESD_5V_DIO
x16 VDD P9 VSS HIZ9 OUT9 OSS_ESD_5V_DIO
.ends

* expanding   symbol:  OSS_ESD_5V_DIO.sym # of pins=6
** sym_path: /Users/okamura/Dropbox/91_OpenPDK/TR-1um/libs.tech/xschem/TR-1um_frame/OSS_ESD_5V_DIO.sym
** sch_path: /Users/okamura/Dropbox/91_OpenPDK/TR-1um/libs.tech/xschem/TR-1um_frame/OSS_ESD_5V_DIO.sch
.subckt OSS_ESD_5V_DIO VDD PAD VSS HIZ OUT
*.PININFO PAD:B VDD:B VSS:B HIZ:I OUT:I
MXM1 PAD PG VDD VDD PMOS w=300u l=2u
MXM2 PAD NG VSS VSS NMOSE w=150u l=2u
MXM3 PG PGG VDD VDD PMOS w=20.8u l=1u
MXM4 PG PGG VSS VSS NMOS w=6.8u l=1u
MXM5 PAD VDD VDD VDD PMOS w=200u l=2u
MXM6 PAD VSS VSS VSS NMOSE w=350u l=2u
MXM7 NG NGG VDD VDD PMOS w=20.8u l=1u
MXM8 NG NGG VSS VSS NMOS w=6.8u l=1u
MXM9 PGG HIZ net2 VDD PMOS w=10.4u l=1u
MXM10 net2 net1 VDD VDD PMOS w=10.4u l=1u
MXM11 PGG net1 VSS VSS NMOS w=3.4u l=1u
MXM12 PGG HIZ VSS VSS NMOS w=3.4u l=1u
MXM13 NGG net1 VDD VDD PMOS w=5.2u l=1u
MXM14 NGG ENB VDD VDD PMOS w=5.2u l=1u
MXM15 NGG ENB net3 VSS NMOS w=3.4u l=1u
MXM16 net3 net1 VSS VSS NMOS w=3.4u l=1u
MXM17 ENB HIZ VDD VDD PMOS w=5.2u l=1u
MXM18 ENB HIZ VSS VSS NMOS w=3.4u l=1u
DD1 VSS HIZ DN A=12.96p P=14.4u
MXM19 net1 OUT VDD VDD PMOS w=5.2u l=1u
MXM20 net1 OUT VSS VSS NMOS w=3.4u l=1u
DD2 VSS OUT DN A=12.96p P=14.4u
.ends

* expanding   symbol:  OSS_ESD_5V_VDD.sym # of pins=3
** sym_path: /Users/okamura/Dropbox/91_OpenPDK/TR-1um/libs.tech/xschem/TR-1um_frame/OSS_ESD_5V_VDD.sym
** sch_path: /Users/okamura/Dropbox/91_OpenPDK/TR-1um/libs.tech/xschem/TR-1um_frame/OSS_ESD_5V_VDD.sch
.subckt OSS_ESD_5V_VDD VDD VSS
*.PININFO VSS:B VDD:B VDD:B
MXM5 VSS VDD VDD VDD PMOS w=500u l=2u
MXM6 VDD VSS VSS VSS NMOSE w=500u l=2u
.ends

* expanding   symbol:  OSS_ESD_5V_VSS.sym # of pins=3
** sym_path: /Users/okamura/Dropbox/91_OpenPDK/TR-1um/libs.tech/xschem/TR-1um_frame/OSS_ESD_5V_VSS.sym
** sch_path: /Users/okamura/Dropbox/91_OpenPDK/TR-1um/libs.tech/xschem/TR-1um_frame/OSS_ESD_5V_VSS.sch
.subckt OSS_ESD_5V_VSS VDD VSS
*.PININFO VSS:B VDD:B VSS:B
MXM3 VSS VDD VDD VDD PMOS w=500u l=2u
MXM4 VDD VSS VSS VSS NMOSE w=500u l=2u
.ends

** Generated by script/gen_lvs_spice_v10.py from i2c_slave_async_net_v10_final.v
** (MUXDFFRB/RSLATCH bodies sourced from simulations/MUXDFFRB.spice and
** simulations/RSLATCH.spice per user instruction -- see module docstring)
.subckt i2c_slave_async_nrow_fm rst_n scl sda_in tx_data[0] tx_data[1] tx_data[2] tx_data[3] tx_data[4]
+ tx_data[5] tx_data[6] tx_data[7] sda_oe rx_data[0] rx_data[1] rx_data[2] rx_data[3] rx_data[4] rx_data[5]
+ rx_data[6] rx_data[7] rx_valid addr_match rw busy VDD GND
*.PININFO rst_n:I scl:I sda_in:I tx_data[0]:I tx_data[1]:I tx_data[2]:I tx_data[3]:I tx_data[4]:I tx_data[5]:I
+ tx_data[6]:I tx_data[7]:I sda_oe:O rx_data[0]:O rx_data[1]:O rx_data[2]:O rx_data[3]:O rx_data[4]:O
+ rx_data[5]:O rx_data[6]:O rx_data[7]:O rx_valid:O addr_match:O rw:O busy:O VDD:B GND:B
x_380_ VDD bit_cnt[0] _079_ GND INV_X1
x_381_ VDD addr_match _080_ GND INV_X1
x_382_ VDD rst_n _081_ GND INV_X1
x_383_ VDD sda_d _082_ GND INV_X1
x_384_ VDD _083_ scl_row1 sda_d GND NAND2
x_385_ VDD _167_ sda_in_row1 _083_ GND NOR2
x_386_ VDD _143_ _081_ _167_ GND OR2
x_387_ VDD _016_ rst_scl_domain_held _143_ GND NOR2
x_388_ VDD _017_ busy rst_n GND AND2_X1
x_389_ VDD _084_ phase[2] _209_ GND OR2
x_390_ VDD _085_ _210_ _084_ GND OR2
x_391_ VDD _085_ rx_valid GND INV_X1
x_392_ phase[0] _209_ VDD _086_ phase[2] GND NOR3
x_393_ VDD _087_ last_bit_pending _086_ GND NAND2
xu_muxdffrb_1 VDD shreg[5] rx_data[6] rx_data[6] _156_ _087_ _195_ GND _016_ MUXDFFRB
xu_muxdffrb_2 VDD shreg[4] rx_data[5] rx_data[5] _156_ _087_ _196_ GND _016_ MUXDFFRB
xu_muxdffrb_3 VDD shreg[3] rx_data[4] rx_data[4] _156_ _087_ _197_ GND _016_ MUXDFFRB
xu_muxdffrb_4 VDD shreg[2] rx_data[3] rx_data[3] _156_ _087_ _198_ GND _016_ MUXDFFRB
xu_muxdffrb_5 VDD shreg[1] rx_data[2] rx_data[2] _156_ _087_ _199_ GND _016_ MUXDFFRB
xu_muxdffrb_6 VDD shreg[0] rx_data[1] rx_data[1] _156_ _087_ _200_ GND _016_ MUXDFFRB
xu_muxdffrb_7 VDD sda_in_row2 rx_data[0] rx_data[0] _156_ _087_ _201_ GND _016_ MUXDFFRB
x_401_ VDD _088_ bit_cnt[1] bit_cnt[0] GND NOR2
x_402_ phase[0] phase[1] VDD _089_ _216_ GND NOR3
x_403_ phase[1] VDD _090_ _216_ phase[0] GND OR3
x_404_ VDD _091_ bit_cnt[2] _090_ GND NOR2
x_405_ VDD _092_ _088_ _091_ GND NAND2
xu_muxdffrb_8 VDD tx_data[6] txreg[6] txreg[6] scl_n_row1 _092_ _202_ GND _017_ MUXDFFRB
xu_muxdffrb_9 VDD tx_data[5] txreg[5] txreg[5] scl_n_row3 _092_ _203_ GND _017_ MUXDFFRB
xu_muxdffrb_10 VDD tx_data[4] txreg[4] txreg[4] scl_n_row3 _092_ _204_ GND _017_ MUXDFFRB
xu_muxdffrb_11 VDD tx_data[3] txreg[3] txreg[3] scl_n_row3 _092_ _205_ GND _017_ MUXDFFRB
xu_muxdffrb_12 VDD tx_data[2] txreg[2] txreg[2] scl_n_row3 _092_ _206_ GND _017_ MUXDFFRB
xu_muxdffrb_13 VDD tx_data[1] txreg[1] txreg[1] scl_n_row3 _092_ _207_ GND _017_ MUXDFFRB
xu_muxdffrb_14 VDD tx_data[0] txreg[0] txreg[0] scl_n_row3 _092_ _208_ GND _017_ MUXDFFRB
x_413_ phase[0] phase[1] VDD _093_ phase[2] GND NOR3
x_414_ _089_ _093_ VDD _094_ _086_ GND NOR3
x_415_ VDD _095_ last_bit_pending _094_ GND NOR2
x_416_ VDD _096_ _210_ phase[1] GND OR2
x_417_ _210_ phase[1] VDD _097_ _216_ GND NOR3
x_418_ VDD _098_ _216_ _096_ GND OR2
x_419_ VDD _099_ phase[2] _096_ GND OR2
x_420_ _099_ _098_ VDD _100_ _085_ _094_ GND AND4_X1
x_421_ VDD _101_ sda_in_row0 _097_ GND NAND2
x_422_ VDD _102_ _080_ _215_ GND NOR2
x_423_ VDD _103_ _099_ _102_ GND NOR2
x_424_ VDD _104_ _087_ _101_ GND NAND2
x_425_ rx_valid _100_ _103_ _104_ VDD _105_ GND OR4
xu_muxdffrb_15 VDD _105_ phase[1] phase[1] _156_ _095_ _209_ GND _016_ MUXDFFRB
x_427_ VDD _106_ last_bit_pending _093_ GND NAND2
x_428_ VDD _107_ last_bit_pending _089_ GND NAND2
x_429_ _107_ VDD _064_ _087_ _106_ GND NAND3
x_430_ VDD _108_ bit_cnt[1] _100_ GND NAND2
x_431_ last_bit_pending _094_ VDD _109_ phase[2] GND NOR3
x_432_ VDD _110_ last_bit_pending _090_ GND AND2_X1
x_433_ VDD _111_ _094_ _110_ GND NOR2
x_434_ VDD _112_ bit_cnt[1] bit_cnt[0] GND NAND2
x_435_ VDD _113_ bit_cnt[1] bit_cnt[0] GND XOR2
x_436_ VDD _114_ _111_ _113_ GND NAND2
x_437_ VDD _065_ _108_ _114_ GND NAND2
x_438_ VDD _115_ bit_cnt[0] _100_ GND NAND2
x_439_ VDD _116_ _212_ _111_ GND NAND2
x_440_ VDD _066_ _115_ _116_ GND NAND2
x_441_ _194_ _191_ shreg[5] shreg[2] VDD _117_ GND OR4
x_442_ shreg[3] shreg[0] shreg[1] _117_ VDD _118_ GND NOR4
xu_muxdffrb_16 VDD _118_ addr_match addr_match _156_ _106_ _213_ GND _016_ MUXDFFRB
x_444_ VDD _119_ bit_cnt[2] _100_ GND NAND2
x_445_ VDD _120_ bit_cnt[2] _112_ GND XNOR2
x_446_ VDD _121_ _111_ _120_ GND NAND2
x_447_ VDD _068_ _119_ _121_ GND NAND2
xu_muxdffrb_17 VDD sda_in_row1 rw rw _156_ _106_ _215_ GND _016_ MUXDFFRB
x_449_ VDD _122_ _080_ rw GND NOR2
x_450_ VDD _123_ _099_ _122_ GND NOR2
x_451_ _097_ _100_ _111_ _123_ VDD _124_ GND NOR4
x_452_ VDD _070_ _109_ _124_ GND NOR2
xu_muxdffrb_18 VDD tx_data[7] txreg[7] txreg[7] scl_n_row1 _092_ _217_ GND _017_ MUXDFFRB
xu_muxdffrb_19 VDD shreg[6] rx_data[7] rx_data[7] _156_ _087_ _188_ GND _016_ MUXDFFRB
x_455_ tx_data[7] txreg[5] bit_cnt[1] VDD _125_ GND MUX2
x_456_ VDD _126_ _079_ _125_ GND NAND2
x_457_ txreg[6] txreg[4] bit_cnt[1] VDD _127_ GND MUX2
x_458_ VDD _128_ bit_cnt[0] _127_ GND NAND2
x_459_ _128_ VDD _129_ _091_ _126_ GND NAND3
x_460_ VDD _130_ bit_cnt[2] _089_ GND NAND2
x_461_ txreg[2] txreg[0] bit_cnt[1] VDD _131_ GND MUX2
x_462_ txreg[3] txreg[1] bit_cnt[1] VDD _132_ GND MUX2
x_463_ _131_ _132_ _079_ VDD _133_ GND MUX2
x_464_ VDD _134_ _130_ _133_ GND NOR2
x_465_ VDD _135_ _080_ _099_ GND NOR2
x_466_ _134_ _135_ VDD _136_ rx_valid GND NOR3
x_467_ VDD _005_ _129_ _136_ GND NAND2
x_468_ _211_ _214_ VDD _004_ bit_cnt[0] GND NOR3
x_469_ VDD _156_ scl_row1 _016_ GND AND2_X1
x_470_ VDD _144_ _081_ scl_row1 GND NOR2
x_471_ _082_ VDD _137_ sda_in_row1 scl_row1 GND NAND3
x_472_ VDD _077_ rst_n _137_ GND NAND2
x_505_ VDD _212_ _066_ bit_cnt[0] _016_ GND _156_ DFFRB
x_506_ VDD _211_ _065_ bit_cnt[1] _016_ GND _156_ DFFRB
x_507_ VDD _214_ _068_ bit_cnt[2] _016_ GND _156_ DFFRB
x_509_ VDD _210_ _064_ phase[0] _016_ GND _156_ DFFRB
x_511_ VDD _216_ _070_ phase[2] _016_ GND _156_ DFFRB
x_528_ VDD sda_oe _005_ sda_oe_r _017_ GND scl_n_row2 DFFRB
x_529_ VDD _186_ _004_ last_bit_pending _016_ GND _156_ DFFRB
x_530_ VDD _192_ sda_in_row3 shreg[0] _016_ GND _156_ DFFRB
x_531_ VDD _189_ shreg[0] shreg[1] _016_ GND _156_ DFFRB
x_532_ VDD _190_ shreg[1] shreg[2] _016_ GND _156_ DFFRB
x_533_ VDD _193_ shreg[2] shreg[3] _016_ GND _156_ DFFRB
x_534_ VDD _191_ shreg[3] shreg[4] _016_ GND _156_ DFFRB
x_535_ VDD _218_ shreg[4] shreg[5] _016_ GND _156_ DFFRB
x_536_ VDD _194_ shreg[5] shreg[6] _016_ GND _156_ DFFRB
xu_inv_scl VDD scl_row1 scl_n GND INV_X1
xu_rslatch_1 VDD _167_ busy _077_ qn GND RSLATCH
xu_rslatch_2 VDD _143_ rst_scl_domain_held _144_ rst_stretch_qn GND RSLATCH
xu_sda_lat_en VDD sda_lat_en busy scl_row1 GND NAND2
xu_rslatch_3 VDD s_in sda_d r_in qn_sda GND RSLATCH
xu_sda_r VDD r_in sda_target_n sda_lat_en GND AND2_X1
xu_sda_s VDD s_in sda_target sda_lat_en GND AND2_X1
xu_sda_target VDD sda_in_row1 busy VDD sda_target GND MUX2
xu_sda_target_n VDD sda_target sda_target_n GND INV_X1
xu_buf_scl_row1 VDD scl_buf scl_row1 GND BUF_X1
xu_buf_scl_n_row1 VDD scl_n scl_n_row1 GND BUF_X1
xu_buf_scl_n_row2 VDD scl_n scl_n_row2 GND BUF_X1
xu_buf_scl_n_row3 VDD scl_n scl_n_row3 GND BUF_X1
xu_bufth_scl VDD scl scl_buf GND BUFTH
xu_bufth_sda_in VDD sda_in sda_in_buf GND BUFTH
xu_buf_sda_in_row0 VDD sda_in_buf sda_in_row0 GND BUF_X1
xu_buf_sda_in_row1 VDD sda_in_buf sda_in_row1 GND BUF_X1
xu_buf_sda_in_row2 VDD sda_in_buf sda_in_row2 GND BUF_X1
xu_buf_sda_in_row3 VDD sda_in_buf sda_in_row3 GND BUF_X1
** FILL3 decoupling-cap devices (design_notes.md 77.47) --
** one PMOS+NMOS pair per real placed instance, L/W from real
** device extraction against LEF/TR-1um_STDCELL.gds.
** FILL2 is instantiated as a subcircuit instead, below
** (design_notes.md round-4 fix, 2026-08-31 -- see
** FILL2_SUBCKT_BODY's comment for why).
xFILL2_1 VDD GND FILL2
xFILL2_2 VDD GND FILL2
xFILL2_3 VDD GND FILL2
xFILL2_4 VDD GND FILL2
xFILL2_5 VDD GND FILL2
xFILL2_6 VDD GND FILL2
xFILL2_7 VDD GND FILL2
xFILL2_8 VDD GND FILL2
xFILL2_9 VDD GND FILL2
xFILL2_10 VDD GND FILL2
xFILL2_11 VDD GND FILL2
xFILL2_12 VDD GND FILL2
xFILL2_13 VDD GND FILL2
xFILL2_14 VDD GND FILL2
xFILL2_15 VDD GND FILL2
xFILL2_16 VDD GND FILL2
xFILL2_17 VDD GND FILL2
xFILL2_18 VDD GND FILL2
xFILL2_19 VDD GND FILL2
xFILL2_20 VDD GND FILL2
xFILL2_21 VDD GND FILL2
xFILL2_22 VDD GND FILL2
xFILL2_23 VDD GND FILL2
xFILL2_24 VDD GND FILL2
xFILL2_25 VDD GND FILL2
xFILL2_26 VDD GND FILL2
xFILL2_27 VDD GND FILL2
xFILL2_28 VDD GND FILL2
xFILL2_29 VDD GND FILL2
xFILL2_30 VDD GND FILL2
xFILL2_31 VDD GND FILL2
xFILL2_32 VDD GND FILL2
xFILL2_33 VDD GND FILL2
M_FILL3_1_p VDD GND VDD VDD PMOS w=21.2u l=8.6u
M_FILL3_1_n GND VDD GND GND NMOS w=13.1u l=8.6u
M_FILL3_2_p VDD GND VDD VDD PMOS w=21.2u l=8.6u
M_FILL3_2_n GND VDD GND GND NMOS w=13.1u l=8.6u
M_FILL3_3_p VDD GND VDD VDD PMOS w=21.2u l=8.6u
M_FILL3_3_n GND VDD GND GND NMOS w=13.1u l=8.6u
M_FILL3_4_p VDD GND VDD VDD PMOS w=21.2u l=8.6u
M_FILL3_4_n GND VDD GND GND NMOS w=13.1u l=8.6u
M_FILL3_5_p VDD GND VDD VDD PMOS w=21.2u l=8.6u
M_FILL3_5_n GND VDD GND GND NMOS w=13.1u l=8.6u
M_FILL3_6_p VDD GND VDD VDD PMOS w=21.2u l=8.6u
M_FILL3_6_n GND VDD GND GND NMOS w=13.1u l=8.6u
M_FILL3_7_p VDD GND VDD VDD PMOS w=21.2u l=8.6u
M_FILL3_7_n GND VDD GND GND NMOS w=13.1u l=8.6u
M_FILL3_8_p VDD GND VDD VDD PMOS w=21.2u l=8.6u
M_FILL3_8_n GND VDD GND GND NMOS w=13.1u l=8.6u
M_FILL3_9_p VDD GND VDD VDD PMOS w=21.2u l=8.6u
M_FILL3_9_n GND VDD GND GND NMOS w=13.1u l=8.6u
M_FILL3_10_p VDD GND VDD VDD PMOS w=21.2u l=8.6u
M_FILL3_10_n GND VDD GND GND NMOS w=13.1u l=8.6u
M_FILL3_11_p VDD GND VDD VDD PMOS w=21.2u l=8.6u
M_FILL3_11_n GND VDD GND GND NMOS w=13.1u l=8.6u
M_FILL3_12_p VDD GND VDD VDD PMOS w=21.2u l=8.6u
M_FILL3_12_n GND VDD GND GND NMOS w=13.1u l=8.6u
M_FILL3_13_p VDD GND VDD VDD PMOS w=21.2u l=8.6u
M_FILL3_13_n GND VDD GND GND NMOS w=13.1u l=8.6u
M_FILL3_14_p VDD GND VDD VDD PMOS w=21.2u l=8.6u
M_FILL3_14_n GND VDD GND GND NMOS w=13.1u l=8.6u
M_FILL3_15_p VDD GND VDD VDD PMOS w=21.2u l=8.6u
M_FILL3_15_n GND VDD GND GND NMOS w=13.1u l=8.6u
M_FILL3_16_p VDD GND VDD VDD PMOS w=21.2u l=8.6u
M_FILL3_16_n GND VDD GND GND NMOS w=13.1u l=8.6u
M_FILL3_17_p VDD GND VDD VDD PMOS w=21.2u l=8.6u
M_FILL3_17_n GND VDD GND GND NMOS w=13.1u l=8.6u
M_FILL3_18_p VDD GND VDD VDD PMOS w=21.2u l=8.6u
M_FILL3_18_n GND VDD GND GND NMOS w=13.1u l=8.6u
M_FILL3_19_p VDD GND VDD VDD PMOS w=21.2u l=8.6u
M_FILL3_19_n GND VDD GND GND NMOS w=13.1u l=8.6u
M_FILL3_20_p VDD GND VDD VDD PMOS w=21.2u l=8.6u
M_FILL3_20_n GND VDD GND GND NMOS w=13.1u l=8.6u
M_FILL3_21_p VDD GND VDD VDD PMOS w=21.2u l=8.6u
M_FILL3_21_n GND VDD GND GND NMOS w=13.1u l=8.6u
M_FILL3_22_p VDD GND VDD VDD PMOS w=21.2u l=8.6u
M_FILL3_22_n GND VDD GND GND NMOS w=13.1u l=8.6u
M_FILL3_23_p VDD GND VDD VDD PMOS w=21.2u l=8.6u
M_FILL3_23_n GND VDD GND GND NMOS w=13.1u l=8.6u
M_FILL3_24_p VDD GND VDD VDD PMOS w=21.2u l=8.6u
M_FILL3_24_n GND VDD GND GND NMOS w=13.1u l=8.6u
M_FILL3_25_p VDD GND VDD VDD PMOS w=21.2u l=8.6u
M_FILL3_25_n GND VDD GND GND NMOS w=13.1u l=8.6u
M_FILL3_26_p VDD GND VDD VDD PMOS w=21.2u l=8.6u
M_FILL3_26_n GND VDD GND GND NMOS w=13.1u l=8.6u
M_FILL3_27_p VDD GND VDD VDD PMOS w=21.2u l=8.6u
M_FILL3_27_n GND VDD GND GND NMOS w=13.1u l=8.6u
M_FILL3_28_p VDD GND VDD VDD PMOS w=21.2u l=8.6u
M_FILL3_28_n GND VDD GND GND NMOS w=13.1u l=8.6u
M_FILL3_29_p VDD GND VDD VDD PMOS w=21.2u l=8.6u
M_FILL3_29_n GND VDD GND GND NMOS w=13.1u l=8.6u
M_FILL3_30_p VDD GND VDD VDD PMOS w=21.2u l=8.6u
M_FILL3_30_n GND VDD GND GND NMOS w=13.1u l=8.6u
M_FILL3_31_p VDD GND VDD VDD PMOS w=21.2u l=8.6u
M_FILL3_31_n GND VDD GND GND NMOS w=13.1u l=8.6u
M_FILL3_32_p VDD GND VDD VDD PMOS w=21.2u l=8.6u
M_FILL3_32_n GND VDD GND GND NMOS w=13.1u l=8.6u
M_FILL3_33_p VDD GND VDD VDD PMOS w=21.2u l=8.6u
M_FILL3_33_n GND VDD GND GND NMOS w=13.1u l=8.6u
M_FILL3_34_p VDD GND VDD VDD PMOS w=21.2u l=8.6u
M_FILL3_34_n GND VDD GND GND NMOS w=13.1u l=8.6u
M_FILL3_35_p VDD GND VDD VDD PMOS w=21.2u l=8.6u
M_FILL3_35_n GND VDD GND GND NMOS w=13.1u l=8.6u
M_FILL3_36_p VDD GND VDD VDD PMOS w=21.2u l=8.6u
M_FILL3_36_n GND VDD GND GND NMOS w=13.1u l=8.6u
M_FILL3_37_p VDD GND VDD VDD PMOS w=21.2u l=8.6u
M_FILL3_37_n GND VDD GND GND NMOS w=13.1u l=8.6u
M_FILL3_38_p VDD GND VDD VDD PMOS w=21.2u l=8.6u
M_FILL3_38_n GND VDD GND GND NMOS w=13.1u l=8.6u
M_FILL3_39_p VDD GND VDD VDD PMOS w=21.2u l=8.6u
M_FILL3_39_n GND VDD GND GND NMOS w=13.1u l=8.6u
M_FILL3_40_p VDD GND VDD VDD PMOS w=21.2u l=8.6u
M_FILL3_40_n GND VDD GND GND NMOS w=13.1u l=8.6u
M_FILL3_41_p VDD GND VDD VDD PMOS w=21.2u l=8.6u
M_FILL3_41_n GND VDD GND GND NMOS w=13.1u l=8.6u
M_FILL3_42_p VDD GND VDD VDD PMOS w=21.2u l=8.6u
M_FILL3_42_n GND VDD GND GND NMOS w=13.1u l=8.6u
M_FILL3_43_p VDD GND VDD VDD PMOS w=21.2u l=8.6u
M_FILL3_43_n GND VDD GND GND NMOS w=13.1u l=8.6u
M_FILL3_44_p VDD GND VDD VDD PMOS w=21.2u l=8.6u
M_FILL3_44_n GND VDD GND GND NMOS w=13.1u l=8.6u
M_FILL3_45_p VDD GND VDD VDD PMOS w=21.2u l=8.6u
M_FILL3_45_n GND VDD GND GND NMOS w=13.1u l=8.6u
M_FILL3_46_p VDD GND VDD VDD PMOS w=21.2u l=8.6u
M_FILL3_46_n GND VDD GND GND NMOS w=13.1u l=8.6u
M_FILL3_47_p VDD GND VDD VDD PMOS w=21.2u l=8.6u
M_FILL3_47_n GND VDD GND GND NMOS w=13.1u l=8.6u
M_FILL3_48_p VDD GND VDD VDD PMOS w=21.2u l=8.6u
M_FILL3_48_n GND VDD GND GND NMOS w=13.1u l=8.6u
M_FILL3_49_p VDD GND VDD VDD PMOS w=21.2u l=8.6u
M_FILL3_49_n GND VDD GND GND NMOS w=13.1u l=8.6u
M_FILL3_50_p VDD GND VDD VDD PMOS w=21.2u l=8.6u
M_FILL3_50_n GND VDD GND GND NMOS w=13.1u l=8.6u
M_FILL3_51_p VDD GND VDD VDD PMOS w=21.2u l=8.6u
M_FILL3_51_n GND VDD GND GND NMOS w=13.1u l=8.6u
M_FILL3_52_p VDD GND VDD VDD PMOS w=21.2u l=8.6u
M_FILL3_52_n GND VDD GND GND NMOS w=13.1u l=8.6u
M_FILL3_53_p VDD GND VDD VDD PMOS w=21.2u l=8.6u
M_FILL3_53_n GND VDD GND GND NMOS w=13.1u l=8.6u
M_FILL3_54_p VDD GND VDD VDD PMOS w=21.2u l=8.6u
M_FILL3_54_n GND VDD GND GND NMOS w=13.1u l=8.6u
M_FILL3_55_p VDD GND VDD VDD PMOS w=21.2u l=8.6u
M_FILL3_55_n GND VDD GND GND NMOS w=13.1u l=8.6u
M_FILL3_56_p VDD GND VDD VDD PMOS w=21.2u l=8.6u
M_FILL3_56_n GND VDD GND GND NMOS w=13.1u l=8.6u
M_FILL3_57_p VDD GND VDD VDD PMOS w=21.2u l=8.6u
M_FILL3_57_n GND VDD GND GND NMOS w=13.1u l=8.6u
M_FILL3_58_p VDD GND VDD VDD PMOS w=21.2u l=8.6u
M_FILL3_58_n GND VDD GND GND NMOS w=13.1u l=8.6u
M_FILL3_59_p VDD GND VDD VDD PMOS w=21.2u l=8.6u
M_FILL3_59_n GND VDD GND GND NMOS w=13.1u l=8.6u
M_FILL3_60_p VDD GND VDD VDD PMOS w=21.2u l=8.6u
M_FILL3_60_n GND VDD GND GND NMOS w=13.1u l=8.6u
M_FILL3_61_p VDD GND VDD VDD PMOS w=21.2u l=8.6u
M_FILL3_61_n GND VDD GND GND NMOS w=13.1u l=8.6u
M_FILL3_62_p VDD GND VDD VDD PMOS w=21.2u l=8.6u
M_FILL3_62_n GND VDD GND GND NMOS w=13.1u l=8.6u
M_FILL3_63_p VDD GND VDD VDD PMOS w=21.2u l=8.6u
M_FILL3_63_n GND VDD GND GND NMOS w=13.1u l=8.6u
M_FILL3_64_p VDD GND VDD VDD PMOS w=21.2u l=8.6u
M_FILL3_64_n GND VDD GND GND NMOS w=13.1u l=8.6u
M_FILL3_65_p VDD GND VDD VDD PMOS w=21.2u l=8.6u
M_FILL3_65_n GND VDD GND GND NMOS w=13.1u l=8.6u
M_FILL3_66_p VDD GND VDD VDD PMOS w=21.2u l=8.6u
M_FILL3_66_n GND VDD GND GND NMOS w=13.1u l=8.6u
M_FILL3_67_p VDD GND VDD VDD PMOS w=21.2u l=8.6u
M_FILL3_67_n GND VDD GND GND NMOS w=13.1u l=8.6u
M_FILL3_68_p VDD GND VDD VDD PMOS w=21.2u l=8.6u
M_FILL3_68_n GND VDD GND GND NMOS w=13.1u l=8.6u
M_FILL3_69_p VDD GND VDD VDD PMOS w=21.2u l=8.6u
M_FILL3_69_n GND VDD GND GND NMOS w=13.1u l=8.6u
M_FILL3_70_p VDD GND VDD VDD PMOS w=21.2u l=8.6u
M_FILL3_70_n GND VDD GND GND NMOS w=13.1u l=8.6u
M_FILL3_71_p VDD GND VDD VDD PMOS w=21.2u l=8.6u
M_FILL3_71_n GND VDD GND GND NMOS w=13.1u l=8.6u
M_FILL3_72_p VDD GND VDD VDD PMOS w=21.2u l=8.6u
M_FILL3_72_n GND VDD GND GND NMOS w=13.1u l=8.6u
M_FILL3_73_p VDD GND VDD VDD PMOS w=21.2u l=8.6u
M_FILL3_73_n GND VDD GND GND NMOS w=13.1u l=8.6u
M_FILL3_74_p VDD GND VDD VDD PMOS w=21.2u l=8.6u
M_FILL3_74_n GND VDD GND GND NMOS w=13.1u l=8.6u
M_FILL3_75_p VDD GND VDD VDD PMOS w=21.2u l=8.6u
M_FILL3_75_n GND VDD GND GND NMOS w=13.1u l=8.6u
M_FILL3_76_p VDD GND VDD VDD PMOS w=21.2u l=8.6u
M_FILL3_76_n GND VDD GND GND NMOS w=13.1u l=8.6u
M_FILL3_77_p VDD GND VDD VDD PMOS w=21.2u l=8.6u
M_FILL3_77_n GND VDD GND GND NMOS w=13.1u l=8.6u
M_FILL3_78_p VDD GND VDD VDD PMOS w=21.2u l=8.6u
M_FILL3_78_n GND VDD GND GND NMOS w=13.1u l=8.6u
M_FILL3_79_p VDD GND VDD VDD PMOS w=21.2u l=8.6u
M_FILL3_79_n GND VDD GND GND NMOS w=13.1u l=8.6u
M_FILL3_80_p VDD GND VDD VDD PMOS w=21.2u l=8.6u
M_FILL3_80_n GND VDD GND GND NMOS w=13.1u l=8.6u
M_FILL3_81_p VDD GND VDD VDD PMOS w=21.2u l=8.6u
M_FILL3_81_n GND VDD GND GND NMOS w=13.1u l=8.6u
M_FILL3_82_p VDD GND VDD VDD PMOS w=21.2u l=8.6u
M_FILL3_82_n GND VDD GND GND NMOS w=13.1u l=8.6u
M_FILL3_83_p VDD GND VDD VDD PMOS w=21.2u l=8.6u
M_FILL3_83_n GND VDD GND GND NMOS w=13.1u l=8.6u
.ends

.subckt FILL2 VDD GND
*.PININFO GND:B VDD:B
MM7 VDD GND VDD VDD PMOS w=21.2u l=3.2u
MM2 GND VDD GND GND NMOS w=13.1u l=3.2u
.ends

** sch_path: /Users/okamura/Dropbox/91_OpenPDK/TR-1um/libs.tech/xschem/IP62_5_stdcell/AND2_X1.sch
.subckt AND2_X1 VDD Y A B GND
*.PININFO Y:O A:I B:I VDD:B GND:B
MM7 net1 B VDD VDD PMOS w=10.2u l=1u
MM1 net1 A VDD VDD PMOS w=10.2u l=1u
MM2 Y net1 VDD VDD PMOS w=10.2u l=1u
MM3 Y net1 GND GND NMOS w=3.4u l=1u
MM4 net1 A net2 GND NMOS w=3.4u l=1u
MM5 net2 B GND GND NMOS w=3.4u l=1u
.ends

** sch_path: /Users/okamura/Dropbox/91_OpenPDK/TR-1um/libs.tech/xschem/IP62_5_stdcell/AND4_X1.sch
.subckt AND4_X1 D C VDD Y A B GND
*.PININFO Y:O A:I B:I VDD:B GND:B C:I D:I
MM7 net1 A net4 GND NMOS w=3.4u l=1u
MM5 net3 C net2 GND NMOS w=3.4u l=1u
MM8 Y net1 GND GND NMOS w=3.4u l=1u
MM10 net2 D GND GND NMOS w=3.4u l=1u
MM6 net4 B net3 GND NMOS w=3.4u l=1u
MM11 net1 A VDD VDD PMOS w=10.2u l=1u
MM1 net1 D VDD VDD PMOS w=10.2u l=1u
MM3 net1 C VDD VDD PMOS w=10.2u l=1u
MM4 Y net1 VDD VDD PMOS w=10.2u l=1u
MM2 net1 B VDD VDD PMOS w=10.2u l=1u
.ends

** sch_path: /Users/okamura/Dropbox/98_LSI_Design/TR-1um_Async_I2C/LEF/BUFTH.sch
.subckt BUFTH VDD A Y GND
*.PININFO A:I Y:O VDD:B GND:B
MM9 MID A net1 VDD PMOS w=5.1u l=1u
MM2 Y MID VDD VDD PMOS w=10.2u l=1u
MM8 MID A net2 GND NMOS w=3.4u l=1u
MM1 Y MID GND GND NMOS w=3.4u l=1u
MM6 GND MID net1 VDD PMOS w=10.2u l=1u
MM3 VDD MID net2 GND NMOS w=6.8u l=1u
MM5 net2 A GND GND NMOS w=3.4u l=1u
MM4 net1 A VDD VDD PMOS w=5.1u l=1u
.ends

** sch_path: /Users/okamura/Dropbox/91_OpenPDK/TR-1um/libs.tech/xschem/IP62_5_stdcell/BUF_X1.sch
.subckt BUF_X1 VDD A Y GND
*.PININFO A:I Y:O VDD:B GND:B
MM7 net1 A VDD VDD PMOS w=10.2u l=1u
MM1 Y net1 VDD VDD PMOS w=10.2u l=1u
MM3 net1 A GND GND NMOS w=3.4u l=1u
MM2 Y net1 GND GND NMOS w=3.4u l=1u
.ends

** sch_path: /Users/okamura/Dropbox/98_LSI_Design/TR-1um_Async_I2C/LEF/DFFRB.sch
.subckt DFFRB VDD QB D Q RSTB GND CK
*.PININFO VDD:B GND:B D:I QB:O CK:I Q:O RSTB:I
MM2 net1 D VDD VDD PMOS w=5.2u l=1u
MM1 net2 CKP net1 VDD PMOS w=5.2u l=1u
MM7 net2 CKB net3 GND NMOS w=3.4u l=1u
MM8 net3 D GND GND NMOS w=3.4u l=1u
MM10 QM net2 VDD VDD PMOS w=5.2u l=1u
MM11 QM net2 GND GND NMOS w=3.4u l=1u
MM13 net4 QM GND GND NMOS w=3.4u l=1u
MM15 net4 CKP net2 GND NMOS w=3.4u l=1u
MM22 QB QS VDD VDD PMOS w=10.4u l=1u
MM3 net4 QM VDD VDD PMOS w=5.2u l=1u
MM4 net2 CKB net4 VDD PMOS w=5.2u l=1u
MM5 QS CKP QM GND NMOS w=3.4u l=1u
MM6 QM CKB QS VDD PMOS w=5.2u l=1u
MM9 net5 QB GND GND NMOS w=3.4u l=1u
MM12 net5 QB VDD VDD PMOS w=5.2u l=1u
MM14 net5 CKB QS GND NMOS w=3.4u l=1u
MM16 QS CKP net5 VDD PMOS w=5.2u l=1u
MM17 QB RSTB net6 GND NMOS w=3.4u l=1u
MM18 Q QB VDD VDD PMOS w=10.4u l=1u
MM19 Q QB GND GND NMOS w=3.4u l=1u
MM20 CKB CK VDD VDD PMOS w=10.4u l=1u
MM21 CKB CK GND GND NMOS w=3.4u l=1u
MM23 CKP CKB VDD VDD PMOS w=10.4u l=1u
MM24 CKP CKB GND GND NMOS w=3.4u l=1u
MM25 net6 QS GND GND NMOS w=3.4u l=1u
MM26 QB RSTB VDD VDD PMOS w=10.4u l=1u
.ends

.subckt INV_X1 VDD A Y GND
*.PININFO A:I Y:O GND:B VDD:B
MM7 Y A VDD VDD PMOS w=10.2u l=1u
MM2 Y A GND GND NMOS w=3.4u l=1u
.ends

** sch_path: /Users/okamura/Dropbox/91_OpenPDK/TR-1um/libs.tech/xschem/IP62_5_stdcell/MUX2.sch
.subckt MUX2 A B S VDD Y GND
*.PININFO S:I Y:O VDD:B GND:B B:I A:I
MM13 SB S VDD VDD PMOS w=6.8u l=1u
MM8 net2 S net3 VDD PMOS w=6.8u l=1u
MM12 SB S GND GND NMOS w=3.4u l=1u
MM6 net2 SB net3 GND NMOS w=3.4u l=1u
MM11 net1 B VDD VDD PMOS w=6.8u l=1u
MM14 net1 B GND GND NMOS w=3.4u l=1u
MM15 net2 A VDD VDD PMOS w=6.8u l=1u
MM16 net2 A GND GND NMOS w=3.4u l=1u
MM3 net1 SB net3 VDD PMOS w=6.8u l=1u
MM5 net1 S net3 GND NMOS w=3.4u l=1u
MM1 Y net3 VDD VDD PMOS w=11.2u l=1u
MM2 Y net3 GND GND NMOS w=3.4u l=1u
.ends

.subckt MUXDFFRB VDD A Q B CK S QB VSS RSTB
*.PININFO A:I B:I CK:I Q:O QB:O VDD:B VSS:B S:I RSTB:I
Mx1_MM2 x1_net1 net1 VDD VDD PMOS w=5.2u l=1u
Mx1_MM1 x1_net2 x1_CKP x1_net1 VDD PMOS w=5.2u l=1u
Mx1_MM7 x1_net2 x1_CKB x1_net3 VSS NMOS w=3.4u l=1u
Mx1_MM8 x1_net3 net1 VSS VSS NMOS w=3.4u l=1u
Mx1_MM10 x1_QM x1_net2 VDD VDD PMOS w=5.2u l=1u
Mx1_MM11 x1_QM x1_net2 VSS VSS NMOS w=3.4u l=1u
Mx1_MM13 x1_net4 x1_QM VSS VSS NMOS w=3.4u l=1u
Mx1_MM15 x1_net4 x1_CKP x1_net2 VSS NMOS w=3.4u l=1u
Mx1_MM22 QB x1_QS VDD VDD PMOS w=10.4u l=1u
Mx1_MM3 x1_net4 x1_QM VDD VDD PMOS w=5.2u l=1u
Mx1_MM4 x1_net2 x1_CKB x1_net4 VDD PMOS w=5.2u l=1u
Mx1_MM5 x1_QS x1_CKP x1_QM VSS NMOS w=3.4u l=1u
Mx1_MM6 x1_QM x1_CKB x1_QS VDD PMOS w=5.2u l=1u
Mx1_MM9 x1_net5 QB VSS VSS NMOS w=3.4u l=1u
Mx1_MM12 x1_net5 QB VDD VDD PMOS w=5.2u l=1u
Mx1_MM14 x1_net5 x1_CKB x1_QS VSS NMOS w=3.4u l=1u
Mx1_MM16 x1_QS x1_CKP x1_net5 VDD PMOS w=5.2u l=1u
Mx1_MM17 QB RSTB x1_net6 VSS NMOS w=3.4u l=1u
Mx1_MM18 Q QB VDD VDD PMOS w=10.4u l=1u
Mx1_MM19 Q QB VSS VSS NMOS w=3.4u l=1u
Mx1_MM20 x1_CKB CK VDD VDD PMOS w=10.4u l=1u
Mx1_MM21 x1_CKB CK VSS VSS NMOS w=3.4u l=1u
Mx1_MM23 x1_CKP x1_CKB VDD VDD PMOS w=10.4u l=1u
Mx1_MM24 x1_CKP x1_CKB VSS VSS NMOS w=3.4u l=1u
Mx1_MM25 x1_net6 x1_QS VSS VSS NMOS w=3.4u l=1u
Mx1_MM26 QB RSTB VDD VDD PMOS w=10.4u l=1u
Mx2_MM13 x2_SB S VDD VDD PMOS w=6.8u l=1u
Mx2_MM8 x2_net2 S x2_net3 VDD PMOS w=6.8u l=1u
Mx2_MM12 x2_SB S VSS VSS NMOS w=3.4u l=1u
Mx2_MM6 x2_net2 x2_SB x2_net3 VSS NMOS w=3.4u l=1u
Mx2_MM11 x2_net1 B VDD VDD PMOS w=6.8u l=1u
Mx2_MM14 x2_net1 B VSS VSS NMOS w=3.4u l=1u
Mx2_MM15 x2_net2 A VDD VDD PMOS w=6.8u l=1u
Mx2_MM16 x2_net2 A VSS VSS NMOS w=3.4u l=1u
Mx2_MM3 x2_net1 x2_SB x2_net3 VDD PMOS w=6.8u l=1u
Mx2_MM5 x2_net1 S x2_net3 VSS NMOS w=3.4u l=1u
Mx2_MM1 net1 x2_net3 VDD VDD PMOS w=11.2u l=1u
Mx2_MM2 net1 x2_net3 VSS VSS NMOS w=3.4u l=1u
.ends

** sch_path: /Users/okamura/Dropbox/91_OpenPDK/TR-1um/libs.tech/xschem/IP62_5_stdcell/NAND2.sch
.subckt NAND2 VDD Y A B GND
*.PININFO B:I A:I Y:O GND:B VDD:B
MM7 Y A VDD VDD PMOS w=10.2u l=1u
MM1 Y B VDD VDD PMOS w=10.2u l=1u
MM2 Y B net1 GND NMOS w=3.4u l=1u
MM3 net1 A GND GND NMOS w=3.4u l=1u
.ends

** sch_path: /Users/okamura/Dropbox/91_OpenPDK/TR-1um/libs.tech/xschem/IP62_5_stdcell/NAND3.sch
.subckt NAND3 C VDD Y A B GND
*.PININFO B:I A:I Y:O GND:B VDD:B C:I
MM1 Y A VDD VDD PMOS w=10.2u l=1u
MM4 Y B VDD VDD PMOS w=10.2u l=1u
MM6 Y C VDD VDD PMOS w=10.2u l=1u
MM7 Y C net1 GND NMOS w=3.4u l=1u
MM2 net1 B net2 GND NMOS w=3.4u l=1u
MM3 net2 A GND GND NMOS w=3.4u l=1u
.ends

** sch_path: /Users/okamura/Dropbox/91_OpenPDK/TR-1um/libs.tech/xschem/IP62_5_stdcell/NOR2.sch
.subckt NOR2 VDD Y A B GND
*.PININFO A:I B:I Y:O VDD:B GND:B
MM7 net1 A VDD VDD PMOS w=10.2u l=1u
MM1 Y B net1 VDD PMOS w=10.2u l=1u
MM2 Y A GND GND NMOS w=3.4u l=1u
MM3 Y B GND GND NMOS w=3.4u l=1u
.ends

** sch_path: /Users/okamura/Dropbox/91_OpenPDK/TR-1um/libs.tech/xschem/IP62_5_stdcell/NOR3.sch
.subckt NOR3 B C VDD Y A GND
*.PININFO A:I B:I Y:O VDD:B GND:B C:I
MM7 net1 B VDD VDD PMOS w=10.2u l=1u
MM2 net2 A net1 VDD PMOS w=10.2u l=1u
MM3 Y C net2 VDD PMOS w=10.2u l=1u
MM1 Y B GND GND NMOS w=3.4u l=1u
MM4 Y C GND GND NMOS w=3.4u l=1u
MM5 Y A GND GND NMOS w=3.4u l=1u
.ends

** sch_path: /Users/okamura/Dropbox/91_OpenPDK/TR-1um/libs.tech/xschem/IP62_5_stdcell/NOR4.sch
.subckt NOR4 A B C D VDD Y GND
*.PININFO A:I B:I Y:O VDD:B GND:B C:I D:I
MM8 net1 B VDD VDD PMOS w=10.2u l=1u
MM2 net2 A net1 VDD PMOS w=10.2u l=1u
MM3 net3 C net2 VDD PMOS w=10.2u l=1u
MM6 Y D net3 VDD PMOS w=10.2u l=1u
MM9 Y D GND GND NMOS w=3.4u l=1u
MM1 Y B GND GND NMOS w=3.4u l=1u
MM4 Y C GND GND NMOS w=3.4u l=1u
MM5 Y A GND GND NMOS w=3.4u l=1u
.ends

** sch_path: /Users/okamura/Dropbox/91_OpenPDK/TR-1um/libs.tech/xschem/IP62_5_stdcell/OR2.sch
.subckt OR2 VDD Y A B GND
*.PININFO A:I B:I Y:O VDD:B GND:B
MM7 net2 B VDD VDD PMOS w=10.2u l=1u
MM2 net1 A net2 VDD PMOS w=10.2u l=1u
MM4 Y net1 VDD VDD PMOS w=10.2u l=1u
MM1 net1 B GND GND NMOS w=3.4u l=1u
MM3 net1 A GND GND NMOS w=3.4u l=1u
MM5 Y net1 GND GND NMOS w=3.4u l=1u
.ends

** sch_path: /Users/okamura/Dropbox/91_OpenPDK/TR-1um/libs.tech/xschem/IP62_5_stdcell/OR3.sch
.subckt OR3 C VDD Y A B GND
*.PININFO A:I B:I Y:O VDD:B GND:B C:I
MM8 net1 B VDD VDD PMOS w=10.2u l=1u
MM2 net2 A net1 VDD PMOS w=10.2u l=1u
MM3 net3 C net2 VDD PMOS w=10.2u l=1u
MM7 Y net3 VDD VDD PMOS w=10.2u l=1u
MM9 Y net3 GND GND NMOS w=3.4u l=1u
MM1 net3 C GND GND NMOS w=3.4u l=1u
MM4 net3 A GND GND NMOS w=3.4u l=1u
MM5 net3 B GND GND NMOS w=3.4u l=1u
.ends

** sch_path: /Users/okamura/Dropbox/91_OpenPDK/TR-1um/libs.tech/xschem/IP62_5_stdcell/OR4.sch
.subckt OR4 A B C D VDD Y GND
*.PININFO B:I A:I Y:O VDD:B GND:B C:I D:I
MM10 net1 B VDD VDD PMOS w=10.2u l=1u
MM2 net2 A net1 VDD PMOS w=10.2u l=1u
MM3 net4 C net2 VDD PMOS w=10.2u l=1u
MM7 Y net3 VDD VDD PMOS w=10.2u l=1u
MM9 net4 D net3 VDD PMOS w=10.2u l=1u
MM11 net3 A GND GND NMOS w=3.4u l=1u
MM1 net3 B GND GND NMOS w=3.4u l=1u
MM4 net3 C GND GND NMOS w=3.4u l=1u
MM5 net3 D GND GND NMOS w=3.4u l=1u
MM6 Y net3 GND GND NMOS w=3.4u l=1u
.ends

.subckt RSLATCH VDD S Q R QB VSS
*.PININFO R:I S:I Q:O QB:O VDD:B VSS:B
Mx1_MM7 x1_net1 R VDD VDD PMOS w=10.2u l=1u
Mx1_MM1 Q QB x1_net1 VDD PMOS w=10.2u l=1u
Mx1_MM2 Q R VSS VSS NMOS w=3.4u l=1u
Mx1_MM3 Q QB VSS VSS NMOS w=3.4u l=1u
Mx2_MM7 x2_net1 S VDD VDD PMOS w=10.2u l=1u
Mx2_MM1 QB Q x2_net1 VDD PMOS w=10.2u l=1u
Mx2_MM2 QB S VSS VSS NMOS w=3.4u l=1u
Mx2_MM3 QB Q VSS VSS NMOS w=3.4u l=1u
.ends

** sch_path: /Users/okamura/Dropbox/98_LSI_Design/TR-1um_Async_I2C/LEF/XNOR2.sch
.subckt XNOR2 VDD Y A B GND
*.PININFO VDD:B GND:B A:I B:I Y:O
MM10 net1 A VDD VDD PMOS w=10.2u l=1u
MM1 net1 B VDD VDD PMOS w=10.2u l=1u
MM2 Y net1 VDD VDD PMOS w=10.2u l=1u
MM3 net4 B VDD VDD PMOS w=10.2u l=1u
MM4 Y A net4 VDD PMOS w=10.2u l=1u
MM11 net1 B net3 GND NMOS w=3.4u l=1u
MM5 net3 A GND GND NMOS w=3.4u l=1u
MM6 Y net1 net2 GND NMOS w=3.4u l=1u
MM7 net2 A GND GND NMOS w=3.4u l=1u
MM8 net2 B GND GND NMOS w=3.4u l=1u
.ends

** sch_path: /Users/okamura/Dropbox/98_LSI_Design/TR-1um_Async_I2C/LEF/XOR2.sch
.subckt XOR2 VDD Y A B GND
*.PININFO VDD:B GND:B A:I B:I Y:O
MM10 net1 A VDD VDD PMOS w=10.2u l=1u
MM1 net2 B net1 VDD PMOS w=10.2u l=1u
MM8 net3 A VDD VDD PMOS w=10.2u l=1u
MM2 net3 B VDD VDD PMOS w=10.2u l=1u
MM9 Y net2 net3 VDD PMOS w=10.2u l=1u
MM3 net2 A GND GND NMOS w=3.4u l=1u
MM4 net2 B GND GND NMOS w=3.4u l=1u
MM5 Y net2 GND GND NMOS w=3.4u l=1u
MM7 net4 B GND GND NMOS w=3.4u l=1u
MM6 Y A net4 GND NMOS w=3.4u l=1u
.ends

** tr_1um_i2c_slave_async.spice -- RING_OSC-INTEGRATED chip-level LVS reference
** netlist (V10). Generated by script/gen_lvs_spice_ringosc_v10.py from:
**   1) ring_osc/simulation/RING_OSC.spice (RING_OSC transistor-level
**      netlist -- UNCHANGED from V9, same GDS/schematic), kept NESTED
**      verbatim -- .subckt RING_OSC plus its own INV3D/FILL2/INV_X1/
**      AND2_X1 dependency subckts, called via one top-level x3 instance
**      (INV_X1/AND2_X1 deduped against the core's own identical copies;
**      INV3D/FILL2 are new and included as-is -- NOT flattened, NOT
**      renamed, NOT dropped, matching V9's own final revision after
**      independent verification via klayout.db.NetlistComparer that
**      INV3D hierarchizes correctly on the layout side).
**   2) schematic/tr_1um_i2c_slave_async_v10_lvs.spice (V10's core+GIO chip
**      LVS reference netlist, from gen_lvs_spice_top_v10.py -- x1=
**      OSS_FRAME_GIO, x2=i2c_slave_async_nrow_fm carried over verbatim)
**   3) schematic/v10_signal_routing_plan.json's own "rst_n" entry
**      (terminal=P15) for ENB's target net -- OUT->OUT10/
**      OUTD->OUT9 are GIO-frame-fixed driver-input pins, unrelated to
**      the V10 pad reassignment, same as V9.
**
** x3 = RING_OSC, added to the existing top subckt with nets
** (OUT10, OUT9, P15, VDD, VSS) -- P15 is
** confirmed (by direct read of the base LVS file's own top subckt
** declaration) to be a real top-level chip pin, the SAME net already
** carrying the core's own rst_n pin (x2's first net) -- ENB and rst_n
** are intentionally the same net (design_notes.md 108.57's ENB
** re-routing physically merges RING_OSC's ENB wire directly onto
** rst_n's own GIO-side wire via a via, matching this schematic tie).

.subckt INV3D VDD A Y GND
*.PININFO A:I Y:O GND:B VDD:B
MM7 Y A VDD VDD PMOS w=10.2u l=1u
MM2 Y A GND GND NMOS w=3.4u l=1u
.ends

.subckt RING_OSC OUT OUTD ENB VDD VSS
*.PININFO OUT:O OUTD:O ENB:I VDD:B VSS:B
x1[0] VDD FB R[0] VSS INV_X1
x1[1] VDD R[0] R[1] VSS INV_X1
x1[2] VDD R[1] R[2] VSS INV_X1
x1[3] VDD R[2] R[3] VSS INV_X1
x1[4] VDD R[3] R[4] VSS INV_X1
x1[5] VDD R[4] R[5] VSS INV_X1
x1[6] VDD R[5] R[6] VSS INV_X1
x1[7] VDD R[6] R[7] VSS INV_X1
x1[8] VDD R[7] R[8] VSS INV_X1
x1[9] VDD R[8] R[9] VSS INV_X1
x1[10] VDD R[9] R[10] VSS INV_X1
x1[11] VDD R[10] R[11] VSS INV_X1
x1[12] VDD R[11] R[12] VSS INV_X1
x1[13] VDD R[12] R[13] VSS INV_X1
x1[14] VDD R[13] R[14] VSS INV_X1
x1[15] VDD R[14] R[15] VSS INV_X1
x1[16] VDD R[15] R[16] VSS INV_X1
x1[17] VDD R[16] R[17] VSS INV_X1
x1[18] VDD R[17] R[18] VSS INV_X1
x1[19] VDD R[18] R[19] VSS INV_X1
x1[20] VDD R[19] R[20] VSS INV_X1
x1[21] VDD R[20] R[21] VSS INV_X1
x1[22] VDD R[21] R[22] VSS INV_X1
x1[23] VDD R[22] R[23] VSS INV_X1
x1[24] VDD R[23] R[24] VSS INV_X1
x1[25] VDD R[24] R[25] VSS INV_X1
x1[26] VDD R[25] R[26] VSS INV_X1
x1[27] VDD R[26] R[27] VSS INV_X1
x1[28] VDD R[27] R[28] VSS INV_X1
x1[29] VDD R[28] R[29] VSS INV_X1
x1[30] VDD R[29] R[30] VSS INV_X1
x1[31] VDD R[30] R[31] VSS INV_X1
x1[32] VDD R[31] R[32] VSS INV_X1
x1[33] VDD R[32] R[33] VSS INV_X1
x1[34] VDD R[33] R[34] VSS INV_X1
x1[35] VDD R[34] R[35] VSS INV_X1
x1[36] VDD R[35] R[36] VSS INV_X1
x1[37] VDD R[36] R[37] VSS INV_X1
x1[38] VDD R[37] R[38] VSS INV_X1
x1[39] VDD R[38] R[39] VSS INV_X1
x1[40] VDD R[39] R[40] VSS INV_X1
x1[41] VDD R[40] R[41] VSS INV_X1
x1[42] VDD R[41] R[42] VSS INV_X1
x1[43] VDD R[42] R[43] VSS INV_X1
x1[44] VDD R[43] R[44] VSS INV_X1
x1[45] VDD R[44] R[45] VSS INV_X1
x1[46] VDD R[45] R[46] VSS INV_X1
x1[47] VDD R[46] R[47] VSS INV_X1
x1[48] VDD R[47] R[48] VSS INV_X1
x1[49] VDD R[48] R[49] VSS INV_X1
x1[50] VDD R[49] R[50] VSS INV_X1
x1[51] VDD R[50] R[51] VSS INV_X1
x1[52] VDD R[51] R[52] VSS INV_X1
x1[53] VDD R[52] R[53] VSS INV_X1
x1[54] VDD R[53] R[54] VSS INV_X1
x1[55] VDD R[54] R[55] VSS INV_X1
x1[56] VDD R[55] R[56] VSS INV_X1
x1[57] VDD R[56] R[57] VSS INV_X1
x1[58] VDD R[57] R[58] VSS INV_X1
x1[59] VDD R[58] R[59] VSS INV_X1
x1[60] VDD R[59] R[60] VSS INV_X1
x1[61] VDD R[60] R[61] VSS INV_X1
x1[62] VDD R[61] R[62] VSS INV_X1
x1[63] VDD R[62] R[63] VSS INV_X1
x1[64] VDD R[63] R[64] VSS INV_X1
x1[65] VDD R[64] R[65] VSS INV_X1
x1[66] VDD R[65] R[66] VSS INV_X1
x1[67] VDD R[66] R[67] VSS INV_X1
x1[68] VDD R[67] R[68] VSS INV_X1
x1[69] VDD R[68] R[69] VSS INV_X1
x1[70] VDD R[69] R[70] VSS INV_X1
x1[71] VDD R[70] R[71] VSS INV_X1
x1[72] VDD R[71] R[72] VSS INV_X1
x1[73] VDD R[72] R[73] VSS INV_X1
x1[74] VDD R[73] R[74] VSS INV_X1
x1[75] VDD R[74] R[75] VSS INV_X1
x1[76] VDD R[75] R[76] VSS INV_X1
x1[77] VDD R[76] R[77] VSS INV_X1
x1[78] VDD R[77] R[78] VSS INV_X1
x1[79] VDD R[78] R[79] VSS INV_X1
x1[80] VDD R[79] R[80] VSS INV_X1
x1[81] VDD R[80] R[81] VSS INV_X1
x1[82] VDD R[81] R[82] VSS INV_X1
x1[83] VDD R[82] R[83] VSS INV_X1
x1[84] VDD R[83] R[84] VSS INV_X1
x1[85] VDD R[84] R[85] VSS INV_X1
x1[86] VDD R[85] R[86] VSS INV_X1
x1[87] VDD R[86] R[87] VSS INV_X1
x1[88] VDD R[87] R[88] VSS INV_X1
x1[89] VDD R[88] R[89] VSS INV_X1
x1[90] VDD R[89] R[90] VSS INV_X1
x1[91] VDD R[90] R[91] VSS INV_X1
x1[92] VDD R[91] R[92] VSS INV_X1
x1[93] VDD R[92] R[93] VSS INV_X1
x1[94] VDD R[93] R[94] VSS INV_X1
x1 VDD FB R[94] ENB VSS AND2_X1
x3 VDD FB OUT VSS INV_X1
x2 VDD FD D[94] ENB VSS AND2_X1
x4 VDD FD OUTD VSS INV_X1
x5[0] VDD VSS FILL2
x5[1] VDD VSS FILL2
x5[2] VDD VSS FILL2
x5[3] VDD VSS FILL2
x5[4] VDD VSS FILL2
x5[5] VDD VSS FILL2
x5[6] VDD VSS FILL2
x5[7] VDD VSS FILL2
x5[8] VDD VSS FILL2
x5[9] VDD VSS FILL2
x5[10] VDD VSS FILL2
x5[11] VDD VSS FILL2
x5[12] VDD VSS FILL2
x5[13] VDD VSS FILL2
x5[14] VDD VSS FILL2
x5[15] VDD VSS FILL2
x3[0] VDD VSS FILL2
x3[1] VDD VSS FILL2
x3[2] VDD VSS FILL2
x3[3] VDD VSS FILL2
x3[4] VDD VSS FILL2
x3[5] VDD VSS FILL2
x3[6] VDD VSS FILL2
x3[7] VDD VSS FILL2
x3[8] VDD VSS FILL2
x3[9] VDD VSS FILL2
x3[10] VDD VSS FILL2
x3[11] VDD VSS FILL2
x3[12] VDD VSS FILL2
x3[13] VDD VSS FILL2
x3[14] VDD VSS FILL2
x3[15] VDD VSS FILL2
x3[16] VDD VSS FILL2
x3[17] VDD VSS FILL2
x3[18] VDD VSS FILL2
x3[19] VDD VSS FILL2
x3[20] VDD VSS FILL2
x3[21] VDD VSS FILL2
x3[22] VDD VSS FILL2
x3[23] VDD VSS FILL2
x3[24] VDD VSS FILL2
x3[25] VDD VSS FILL2
x3[26] VDD VSS FILL2
x3[27] VDD VSS FILL2
x3[28] VDD VSS FILL2
x3[29] VDD VSS FILL2
x3[30] VDD VSS FILL2
x3[31] VDD VSS FILL2
x3[32] VDD VSS FILL2
x3[33] VDD VSS FILL2
x3[34] VDD VSS FILL2
x3[35] VDD VSS FILL2
x3[36] VDD VSS FILL2
x3[37] VDD VSS FILL2
x3[38] VDD VSS FILL2
x3[39] VDD VSS FILL2
x3[40] VDD VSS FILL2
x3[41] VDD VSS FILL2
x3[42] VDD VSS FILL2
x3[43] VDD VSS FILL2
x3[44] VDD VSS FILL2
x3[45] VDD VSS FILL2
x3[46] VDD VSS FILL2
x3[47] VDD VSS FILL2
x3[48] VDD VSS FILL2
x3[49] VDD VSS FILL2
x3[50] VDD VSS FILL2
x3[51] VDD VSS FILL2
x3[52] VDD VSS FILL2
x3[53] VDD VSS FILL2
x3[54] VDD VSS FILL2
x3[55] VDD VSS FILL2
x3[56] VDD VSS FILL2
x3[57] VDD VSS FILL2
x3[58] VDD VSS FILL2
x3[59] VDD VSS FILL2
x3[60] VDD VSS FILL2
x3[61] VDD VSS FILL2
x3[62] VDD VSS FILL2
x3[63] VDD VSS FILL2
x3[64] VDD VSS FILL2
x3[65] VDD VSS FILL2
x3[66] VDD VSS FILL2
x3[67] VDD VSS FILL2
x3[68] VDD VSS FILL2
x3[69] VDD VSS FILL2
x3[70] VDD VSS FILL2
x3[71] VDD VSS FILL2
x3[72] VDD VSS FILL2
x3[73] VDD VSS FILL2
x3[74] VDD VSS FILL2
x3[75] VDD VSS FILL2
x3[76] VDD VSS FILL2
x3[77] VDD VSS FILL2
x3[78] VDD VSS FILL2
x3[79] VDD VSS FILL2
x3[80] VDD VSS FILL2
x3[81] VDD VSS FILL2
x3[82] VDD VSS FILL2
x3[83] VDD VSS FILL2
x3[84] VDD VSS FILL2
x3[85] VDD VSS FILL2
x3[86] VDD VSS FILL2
x3[87] VDD VSS FILL2
x3[88] VDD VSS FILL2
x3[89] VDD VSS FILL2
x3[90] VDD VSS FILL2
x3[91] VDD VSS FILL2
x3[92] VDD VSS FILL2
x3[93] VDD VSS FILL2
x3[94] VDD VSS FILL2
x3[95] VDD VSS FILL2
x3[96] VDD VSS FILL2
x3[97] VDD VSS FILL2
x3[98] VDD VSS FILL2
x3[99] VDD VSS FILL2
x3[100] VDD VSS FILL2
x3[101] VDD VSS FILL2
x3[102] VDD VSS FILL2
x3[103] VDD VSS FILL2
x3[104] VDD VSS FILL2
x3[105] VDD VSS FILL2
x3[106] VDD VSS FILL2
x3[107] VDD VSS FILL2
x3[108] VDD VSS FILL2
x3[109] VDD VSS FILL2
x3[110] VDD VSS FILL2
x3[111] VDD VSS FILL2
x3[112] VDD VSS FILL2
x3[113] VDD VSS FILL2
x3[114] VDD VSS FILL2
x3[115] VDD VSS FILL2
x3[116] VDD VSS FILL2
x3[117] VDD VSS FILL2
x3[118] VDD VSS FILL2
x3[119] VDD VSS FILL2
x3[120] VDD VSS FILL2
x3[121] VDD VSS FILL2
x3[122] VDD VSS FILL2
x3[123] VDD VSS FILL2
x3[124] VDD VSS FILL2
x3[125] VDD VSS FILL2
x3[126] VDD VSS FILL2
x3[127] VDD VSS FILL2
x3[128] VDD VSS FILL2
x3[129] VDD VSS FILL2
x3[130] VDD VSS FILL2
x3[131] VDD VSS FILL2
x3[132] VDD VSS FILL2
x3[133] VDD VSS FILL2
x3[134] VDD VSS FILL2
x3[135] VDD VSS FILL2
x3[136] VDD VSS FILL2
x3[137] VDD VSS FILL2
x3[138] VDD VSS FILL2
x3[139] VDD VSS FILL2
x3[140] VDD VSS FILL2
x3[141] VDD VSS FILL2
x3[142] VDD VSS FILL2
x3[143] VDD VSS FILL2
x3[144] VDD VSS FILL2
x3[145] VDD VSS FILL2
x3[146] VDD VSS FILL2
x3[147] VDD VSS FILL2
x3[148] VDD VSS FILL2
x3[149] VDD VSS FILL2
x3[150] VDD VSS FILL2
x3[151] VDD VSS FILL2
x3[152] VDD VSS FILL2
x3[153] VDD VSS FILL2
x3[154] VDD VSS FILL2
x3[155] VDD VSS FILL2
x3[156] VDD VSS FILL2
x3[157] VDD VSS FILL2
x3[158] VDD VSS FILL2
x3[159] VDD VSS FILL2
x3[160] VDD VSS FILL2
x3[161] VDD VSS FILL2
x3[162] VDD VSS FILL2
x3[163] VDD VSS FILL2
x3[164] VDD VSS FILL2
x3[165] VDD VSS FILL2
x3[166] VDD VSS FILL2
x3[167] VDD VSS FILL2
x3[168] VDD VSS FILL2
x3[169] VDD VSS FILL2
x3[170] VDD VSS FILL2
x3[171] VDD VSS FILL2
x3[172] VDD VSS FILL2
x3[173] VDD VSS FILL2
x3[174] VDD VSS FILL2
x3[175] VDD VSS FILL2
x3[176] VDD VSS FILL2
x3[177] VDD VSS FILL2
x3[178] VDD VSS FILL2
x3[179] VDD VSS FILL2
x3[180] VDD VSS FILL2
x3[181] VDD VSS FILL2
x3[182] VDD VSS FILL2
x3[183] VDD VSS FILL2
x3[184] VDD VSS FILL2
x3[185] VDD VSS FILL2
x3[186] VDD VSS FILL2
x3[187] VDD VSS FILL2
x3[188] VDD VSS FILL2
x3[189] VDD VSS FILL2
x54[0] VDD FD D[0] VSS INV3D
x54[1] VDD D[0] D[1] VSS INV3D
x54[2] VDD D[1] D[2] VSS INV3D
x54[3] VDD D[2] D[3] VSS INV3D
x54[4] VDD D[3] D[4] VSS INV3D
x54[5] VDD D[4] D[5] VSS INV3D
x54[6] VDD D[5] D[6] VSS INV3D
x54[7] VDD D[6] D[7] VSS INV3D
x54[8] VDD D[7] D[8] VSS INV3D
x54[9] VDD D[8] D[9] VSS INV3D
x54[10] VDD D[9] D[10] VSS INV3D
x54[11] VDD D[10] D[11] VSS INV3D
x54[12] VDD D[11] D[12] VSS INV3D
x54[13] VDD D[12] D[13] VSS INV3D
x54[14] VDD D[13] D[14] VSS INV3D
x54[15] VDD D[14] D[15] VSS INV3D
x54[16] VDD D[15] D[16] VSS INV3D
x54[17] VDD D[16] D[17] VSS INV3D
x54[18] VDD D[17] D[18] VSS INV3D
x54[19] VDD D[18] D[19] VSS INV3D
x54[20] VDD D[19] D[20] VSS INV3D
x54[21] VDD D[20] D[21] VSS INV3D
x54[22] VDD D[21] D[22] VSS INV3D
x54[23] VDD D[22] D[23] VSS INV3D
x54[24] VDD D[23] D[24] VSS INV3D
x54[25] VDD D[24] D[25] VSS INV3D
x54[26] VDD D[25] D[26] VSS INV3D
x54[27] VDD D[26] D[27] VSS INV3D
x54[28] VDD D[27] D[28] VSS INV3D
x54[29] VDD D[28] D[29] VSS INV3D
x54[30] VDD D[29] D[30] VSS INV3D
x54[31] VDD D[30] D[31] VSS INV3D
x54[32] VDD D[31] D[32] VSS INV3D
x54[33] VDD D[32] D[33] VSS INV3D
x54[34] VDD D[33] D[34] VSS INV3D
x54[35] VDD D[34] D[35] VSS INV3D
x54[36] VDD D[35] D[36] VSS INV3D
x54[37] VDD D[36] D[37] VSS INV3D
x54[38] VDD D[37] D[38] VSS INV3D
x54[39] VDD D[38] D[39] VSS INV3D
x54[40] VDD D[39] D[40] VSS INV3D
x54[41] VDD D[40] D[41] VSS INV3D
x54[42] VDD D[41] D[42] VSS INV3D
x54[43] VDD D[42] D[43] VSS INV3D
x54[44] VDD D[43] D[44] VSS INV3D
x54[45] VDD D[44] D[45] VSS INV3D
x54[46] VDD D[45] D[46] VSS INV3D
x54[47] VDD D[46] D[47] VSS INV3D
x54[48] VDD D[47] D[48] VSS INV3D
x54[49] VDD D[48] D[49] VSS INV3D
x54[50] VDD D[49] D[50] VSS INV3D
x54[51] VDD D[50] D[51] VSS INV3D
x54[52] VDD D[51] D[52] VSS INV3D
x54[53] VDD D[52] D[53] VSS INV3D
x54[54] VDD D[53] D[54] VSS INV3D
x54[55] VDD D[54] D[55] VSS INV3D
x54[56] VDD D[55] D[56] VSS INV3D
x54[57] VDD D[56] D[57] VSS INV3D
x54[58] VDD D[57] D[58] VSS INV3D
x54[59] VDD D[58] D[59] VSS INV3D
x54[60] VDD D[59] D[60] VSS INV3D
x54[61] VDD D[60] D[61] VSS INV3D
x54[62] VDD D[61] D[62] VSS INV3D
x54[63] VDD D[62] D[63] VSS INV3D
x54[64] VDD D[63] D[64] VSS INV3D
x54[65] VDD D[64] D[65] VSS INV3D
x54[66] VDD D[65] D[66] VSS INV3D
x54[67] VDD D[66] D[67] VSS INV3D
x54[68] VDD D[67] D[68] VSS INV3D
x54[69] VDD D[68] D[69] VSS INV3D
x54[70] VDD D[69] D[70] VSS INV3D
x54[71] VDD D[70] D[71] VSS INV3D
x54[72] VDD D[71] D[72] VSS INV3D
x54[73] VDD D[72] D[73] VSS INV3D
x54[74] VDD D[73] D[74] VSS INV3D
x54[75] VDD D[74] D[75] VSS INV3D
x54[76] VDD D[75] D[76] VSS INV3D
x54[77] VDD D[76] D[77] VSS INV3D
x54[78] VDD D[77] D[78] VSS INV3D
x54[79] VDD D[78] D[79] VSS INV3D
x54[80] VDD D[79] D[80] VSS INV3D
x54[81] VDD D[80] D[81] VSS INV3D
x54[82] VDD D[81] D[82] VSS INV3D
x54[83] VDD D[82] D[83] VSS INV3D
x54[84] VDD D[83] D[84] VSS INV3D
x54[85] VDD D[84] D[85] VSS INV3D
x54[86] VDD D[85] D[86] VSS INV3D
x54[87] VDD D[86] D[87] VSS INV3D
x54[88] VDD D[87] D[88] VSS INV3D
x54[89] VDD D[88] D[89] VSS INV3D
x54[90] VDD D[89] D[90] VSS INV3D
x54[91] VDD D[90] D[91] VSS INV3D
x54[92] VDD D[91] D[92] VSS INV3D
x54[93] VDD D[92] D[93] VSS INV3D
x54[94] VDD D[93] D[94] VSS INV3D
.ends

.subckt tr_1um_i2c_slave_async P1 P2 P3 P4 P5 P6 P7 VSS P9 P10 P11 P12 P13 P14 P15 VDD
x1 P1 VDD P2 P15 P14 P3 P4 P13
+ P5 P12 P6 P11 P10 P7 P9 VSS
+ VDD NC_HIZ2 VSS VSS P7 P7 P7 P7
+ P7 P7 P7 P7 VDD VDD NC_OUT1 VSS
+ OUT9 OUT10 NC_OUT3 NC_OUT4 NC_OUT11 NC_OUT5 NC_OUT12 NC_OUT6
+ NC_OUT13 NC_OUT14 NC_OUT7 NC_OUT15 OSS_FRAME_GIO
x2 P15 P1 P2 P3 P4 P5 P6 P11
+ P12 P13 P14 NC_HIZ2 NC_OUT3 NC_OUT4 NC_OUT5 NC_OUT6
+ NC_OUT11 NC_OUT12 NC_OUT13 NC_OUT14 NC_CORE_rx_valid NC_CORE_addr_match NC_CORE_rw NC_CORE_busy
+ VDD VSS i2c_slave_async_nrow_fm
x3 OUT10 OUT9 P15 VDD VSS RING_OSC
.ends
